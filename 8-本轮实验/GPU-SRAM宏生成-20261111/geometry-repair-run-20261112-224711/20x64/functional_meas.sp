.meas tran vdout1_0ck40 FIND v(dout1_0) AT=50.05n

.meas tran vdout1_1ck40 FIND v(dout1_1) AT=50.05n

.meas tran vdout1_2ck40 FIND v(dout1_2) AT=50.05n

.meas tran vdout1_3ck40 FIND v(dout1_3) AT=50.05n

.meas tran vdout1_4ck40 FIND v(dout1_4) AT=50.05n

.meas tran vdout1_5ck40 FIND v(dout1_5) AT=50.05n

.meas tran vdout1_6ck40 FIND v(dout1_6) AT=50.05n

.meas tran vdout1_7ck40 FIND v(dout1_7) AT=50.05n

.meas tran vdout1_8ck40 FIND v(dout1_8) AT=50.05n

.meas tran vdout1_9ck40 FIND v(dout1_9) AT=50.05n

.meas tran vdout1_10ck40 FIND v(dout1_10) AT=50.05n

.meas tran vdout1_11ck40 FIND v(dout1_11) AT=50.05n

.meas tran vdout1_12ck40 FIND v(dout1_12) AT=50.05n

.meas tran vdout1_13ck40 FIND v(dout1_13) AT=50.05n

.meas tran vdout1_14ck40 FIND v(dout1_14) AT=50.05n

.meas tran vdout1_15ck40 FIND v(dout1_15) AT=50.05n

.meas tran vdout1_16ck40 FIND v(dout1_16) AT=50.05n

.meas tran vdout1_17ck40 FIND v(dout1_17) AT=50.05n

.meas tran vdout1_18ck40 FIND v(dout1_18) AT=50.05n

.meas tran vdout1_19ck40 FIND v(dout1_19) AT=50.05n

.meas tran vdout1_0ck50 FIND v(dout1_0) AT=60.05n

.meas tran vdout1_1ck50 FIND v(dout1_1) AT=60.05n

.meas tran vdout1_2ck50 FIND v(dout1_2) AT=60.05n

.meas tran vdout1_3ck50 FIND v(dout1_3) AT=60.05n

.meas tran vdout1_4ck50 FIND v(dout1_4) AT=60.05n

.meas tran vdout1_5ck50 FIND v(dout1_5) AT=60.05n

.meas tran vdout1_6ck50 FIND v(dout1_6) AT=60.05n

.meas tran vdout1_7ck50 FIND v(dout1_7) AT=60.05n

.meas tran vdout1_8ck50 FIND v(dout1_8) AT=60.05n

.meas tran vdout1_9ck50 FIND v(dout1_9) AT=60.05n

.meas tran vdout1_10ck50 FIND v(dout1_10) AT=60.05n

.meas tran vdout1_11ck50 FIND v(dout1_11) AT=60.05n

.meas tran vdout1_12ck50 FIND v(dout1_12) AT=60.05n

.meas tran vdout1_13ck50 FIND v(dout1_13) AT=60.05n

.meas tran vdout1_14ck50 FIND v(dout1_14) AT=60.05n

.meas tran vdout1_15ck50 FIND v(dout1_15) AT=60.05n

.meas tran vdout1_16ck50 FIND v(dout1_16) AT=60.05n

.meas tran vdout1_17ck50 FIND v(dout1_17) AT=60.05n

.meas tran vdout1_18ck50 FIND v(dout1_18) AT=60.05n

.meas tran vdout1_19ck50 FIND v(dout1_19) AT=60.05n

.meas tran vdout1_0ck70 FIND v(dout1_0) AT=80.05n

.meas tran vdout1_1ck70 FIND v(dout1_1) AT=80.05n

.meas tran vdout1_2ck70 FIND v(dout1_2) AT=80.05n

.meas tran vdout1_3ck70 FIND v(dout1_3) AT=80.05n

.meas tran vdout1_4ck70 FIND v(dout1_4) AT=80.05n

.meas tran vdout1_5ck70 FIND v(dout1_5) AT=80.05n

.meas tran vdout1_6ck70 FIND v(dout1_6) AT=80.05n

.meas tran vdout1_7ck70 FIND v(dout1_7) AT=80.05n

.meas tran vdout1_8ck70 FIND v(dout1_8) AT=80.05n

.meas tran vdout1_9ck70 FIND v(dout1_9) AT=80.05n

.meas tran vdout1_10ck70 FIND v(dout1_10) AT=80.05n

.meas tran vdout1_11ck70 FIND v(dout1_11) AT=80.05n

.meas tran vdout1_12ck70 FIND v(dout1_12) AT=80.05n

.meas tran vdout1_13ck70 FIND v(dout1_13) AT=80.05n

.meas tran vdout1_14ck70 FIND v(dout1_14) AT=80.05n

.meas tran vdout1_15ck70 FIND v(dout1_15) AT=80.05n

.meas tran vdout1_16ck70 FIND v(dout1_16) AT=80.05n

.meas tran vdout1_17ck70 FIND v(dout1_17) AT=80.05n

.meas tran vdout1_18ck70 FIND v(dout1_18) AT=80.05n

.meas tran vdout1_19ck70 FIND v(dout1_19) AT=80.05n

.meas tran vdout1_0ck90 FIND v(dout1_0) AT=100.05n

.meas tran vdout1_1ck90 FIND v(dout1_1) AT=100.05n

.meas tran vdout1_2ck90 FIND v(dout1_2) AT=100.05n

.meas tran vdout1_3ck90 FIND v(dout1_3) AT=100.05n

.meas tran vdout1_4ck90 FIND v(dout1_4) AT=100.05n

.meas tran vdout1_5ck90 FIND v(dout1_5) AT=100.05n

.meas tran vdout1_6ck90 FIND v(dout1_6) AT=100.05n

.meas tran vdout1_7ck90 FIND v(dout1_7) AT=100.05n

.meas tran vdout1_8ck90 FIND v(dout1_8) AT=100.05n

.meas tran vdout1_9ck90 FIND v(dout1_9) AT=100.05n

.meas tran vdout1_10ck90 FIND v(dout1_10) AT=100.05n

.meas tran vdout1_11ck90 FIND v(dout1_11) AT=100.05n

.meas tran vdout1_12ck90 FIND v(dout1_12) AT=100.05n

.meas tran vdout1_13ck90 FIND v(dout1_13) AT=100.05n

.meas tran vdout1_14ck90 FIND v(dout1_14) AT=100.05n

.meas tran vdout1_15ck90 FIND v(dout1_15) AT=100.05n

.meas tran vdout1_16ck90 FIND v(dout1_16) AT=100.05n

.meas tran vdout1_17ck90 FIND v(dout1_17) AT=100.05n

.meas tran vdout1_18ck90 FIND v(dout1_18) AT=100.05n

.meas tran vdout1_19ck90 FIND v(dout1_19) AT=100.05n

.meas tran vdout1_0ck120 FIND v(dout1_0) AT=130.05n

.meas tran vdout1_1ck120 FIND v(dout1_1) AT=130.05n

.meas tran vdout1_2ck120 FIND v(dout1_2) AT=130.05n

.meas tran vdout1_3ck120 FIND v(dout1_3) AT=130.05n

.meas tran vdout1_4ck120 FIND v(dout1_4) AT=130.05n

.meas tran vdout1_5ck120 FIND v(dout1_5) AT=130.05n

.meas tran vdout1_6ck120 FIND v(dout1_6) AT=130.05n

.meas tran vdout1_7ck120 FIND v(dout1_7) AT=130.05n

.meas tran vdout1_8ck120 FIND v(dout1_8) AT=130.05n

.meas tran vdout1_9ck120 FIND v(dout1_9) AT=130.05n

.meas tran vdout1_10ck120 FIND v(dout1_10) AT=130.05n

.meas tran vdout1_11ck120 FIND v(dout1_11) AT=130.05n

.meas tran vdout1_12ck120 FIND v(dout1_12) AT=130.05n

.meas tran vdout1_13ck120 FIND v(dout1_13) AT=130.05n

.meas tran vdout1_14ck120 FIND v(dout1_14) AT=130.05n

.meas tran vdout1_15ck120 FIND v(dout1_15) AT=130.05n

.meas tran vdout1_16ck120 FIND v(dout1_16) AT=130.05n

.meas tran vdout1_17ck120 FIND v(dout1_17) AT=130.05n

.meas tran vdout1_18ck120 FIND v(dout1_18) AT=130.05n

.meas tran vdout1_19ck120 FIND v(dout1_19) AT=130.05n

.meas tran vdout1_0ck130 FIND v(dout1_0) AT=140.05n

.meas tran vdout1_1ck130 FIND v(dout1_1) AT=140.05n

.meas tran vdout1_2ck130 FIND v(dout1_2) AT=140.05n

.meas tran vdout1_3ck130 FIND v(dout1_3) AT=140.05n

.meas tran vdout1_4ck130 FIND v(dout1_4) AT=140.05n

.meas tran vdout1_5ck130 FIND v(dout1_5) AT=140.05n

.meas tran vdout1_6ck130 FIND v(dout1_6) AT=140.05n

.meas tran vdout1_7ck130 FIND v(dout1_7) AT=140.05n

.meas tran vdout1_8ck130 FIND v(dout1_8) AT=140.05n

.meas tran vdout1_9ck130 FIND v(dout1_9) AT=140.05n

.meas tran vdout1_10ck130 FIND v(dout1_10) AT=140.05n

.meas tran vdout1_11ck130 FIND v(dout1_11) AT=140.05n

.meas tran vdout1_12ck130 FIND v(dout1_12) AT=140.05n

.meas tran vdout1_13ck130 FIND v(dout1_13) AT=140.05n

.meas tran vdout1_14ck130 FIND v(dout1_14) AT=140.05n

.meas tran vdout1_15ck130 FIND v(dout1_15) AT=140.05n

.meas tran vdout1_16ck130 FIND v(dout1_16) AT=140.05n

.meas tran vdout1_17ck130 FIND v(dout1_17) AT=140.05n

.meas tran vdout1_18ck130 FIND v(dout1_18) AT=140.05n

.meas tran vdout1_19ck130 FIND v(dout1_19) AT=140.05n

.meas tran vdout1_0ck140 FIND v(dout1_0) AT=150.05n

.meas tran vdout1_1ck140 FIND v(dout1_1) AT=150.05n

.meas tran vdout1_2ck140 FIND v(dout1_2) AT=150.05n

.meas tran vdout1_3ck140 FIND v(dout1_3) AT=150.05n

.meas tran vdout1_4ck140 FIND v(dout1_4) AT=150.05n

.meas tran vdout1_5ck140 FIND v(dout1_5) AT=150.05n

.meas tran vdout1_6ck140 FIND v(dout1_6) AT=150.05n

.meas tran vdout1_7ck140 FIND v(dout1_7) AT=150.05n

.meas tran vdout1_8ck140 FIND v(dout1_8) AT=150.05n

.meas tran vdout1_9ck140 FIND v(dout1_9) AT=150.05n

.meas tran vdout1_10ck140 FIND v(dout1_10) AT=150.05n

.meas tran vdout1_11ck140 FIND v(dout1_11) AT=150.05n

.meas tran vdout1_12ck140 FIND v(dout1_12) AT=150.05n

.meas tran vdout1_13ck140 FIND v(dout1_13) AT=150.05n

.meas tran vdout1_14ck140 FIND v(dout1_14) AT=150.05n

.meas tran vdout1_15ck140 FIND v(dout1_15) AT=150.05n

.meas tran vdout1_16ck140 FIND v(dout1_16) AT=150.05n

.meas tran vdout1_17ck140 FIND v(dout1_17) AT=150.05n

.meas tran vdout1_18ck140 FIND v(dout1_18) AT=150.05n

.meas tran vdout1_19ck140 FIND v(dout1_19) AT=150.05n

.meas tran vdout1_0ck180 FIND v(dout1_0) AT=190.05n

.meas tran vdout1_1ck180 FIND v(dout1_1) AT=190.05n

.meas tran vdout1_2ck180 FIND v(dout1_2) AT=190.05n

.meas tran vdout1_3ck180 FIND v(dout1_3) AT=190.05n

.meas tran vdout1_4ck180 FIND v(dout1_4) AT=190.05n

.meas tran vdout1_5ck180 FIND v(dout1_5) AT=190.05n

.meas tran vdout1_6ck180 FIND v(dout1_6) AT=190.05n

.meas tran vdout1_7ck180 FIND v(dout1_7) AT=190.05n

.meas tran vdout1_8ck180 FIND v(dout1_8) AT=190.05n

.meas tran vdout1_9ck180 FIND v(dout1_9) AT=190.05n

.meas tran vdout1_10ck180 FIND v(dout1_10) AT=190.05n

.meas tran vdout1_11ck180 FIND v(dout1_11) AT=190.05n

.meas tran vdout1_12ck180 FIND v(dout1_12) AT=190.05n

.meas tran vdout1_13ck180 FIND v(dout1_13) AT=190.05n

.meas tran vdout1_14ck180 FIND v(dout1_14) AT=190.05n

.meas tran vdout1_15ck180 FIND v(dout1_15) AT=190.05n

.meas tran vdout1_16ck180 FIND v(dout1_16) AT=190.05n

.meas tran vdout1_17ck180 FIND v(dout1_17) AT=190.05n

.meas tran vdout1_18ck180 FIND v(dout1_18) AT=190.05n

.meas tran vdout1_19ck180 FIND v(dout1_19) AT=190.05n

.meas tran vdout1_0ck250 FIND v(dout1_0) AT=260.05n

.meas tran vdout1_1ck250 FIND v(dout1_1) AT=260.05n

.meas tran vdout1_2ck250 FIND v(dout1_2) AT=260.05n

.meas tran vdout1_3ck250 FIND v(dout1_3) AT=260.05n

.meas tran vdout1_4ck250 FIND v(dout1_4) AT=260.05n

.meas tran vdout1_5ck250 FIND v(dout1_5) AT=260.05n

.meas tran vdout1_6ck250 FIND v(dout1_6) AT=260.05n

.meas tran vdout1_7ck250 FIND v(dout1_7) AT=260.05n

.meas tran vdout1_8ck250 FIND v(dout1_8) AT=260.05n

.meas tran vdout1_9ck250 FIND v(dout1_9) AT=260.05n

.meas tran vdout1_10ck250 FIND v(dout1_10) AT=260.05n

.meas tran vdout1_11ck250 FIND v(dout1_11) AT=260.05n

.meas tran vdout1_12ck250 FIND v(dout1_12) AT=260.05n

.meas tran vdout1_13ck250 FIND v(dout1_13) AT=260.05n

.meas tran vdout1_14ck250 FIND v(dout1_14) AT=260.05n

.meas tran vdout1_15ck250 FIND v(dout1_15) AT=260.05n

.meas tran vdout1_16ck250 FIND v(dout1_16) AT=260.05n

.meas tran vdout1_17ck250 FIND v(dout1_17) AT=260.05n

.meas tran vdout1_18ck250 FIND v(dout1_18) AT=260.05n

.meas tran vdout1_19ck250 FIND v(dout1_19) AT=260.05n

.meas tran vdout1_0ck270 FIND v(dout1_0) AT=280.05n

.meas tran vdout1_1ck270 FIND v(dout1_1) AT=280.05n

.meas tran vdout1_2ck270 FIND v(dout1_2) AT=280.05n

.meas tran vdout1_3ck270 FIND v(dout1_3) AT=280.05n

.meas tran vdout1_4ck270 FIND v(dout1_4) AT=280.05n

.meas tran vdout1_5ck270 FIND v(dout1_5) AT=280.05n

.meas tran vdout1_6ck270 FIND v(dout1_6) AT=280.05n

.meas tran vdout1_7ck270 FIND v(dout1_7) AT=280.05n

.meas tran vdout1_8ck270 FIND v(dout1_8) AT=280.05n

.meas tran vdout1_9ck270 FIND v(dout1_9) AT=280.05n

.meas tran vdout1_10ck270 FIND v(dout1_10) AT=280.05n

.meas tran vdout1_11ck270 FIND v(dout1_11) AT=280.05n

.meas tran vdout1_12ck270 FIND v(dout1_12) AT=280.05n

.meas tran vdout1_13ck270 FIND v(dout1_13) AT=280.05n

.meas tran vdout1_14ck270 FIND v(dout1_14) AT=280.05n

.meas tran vdout1_15ck270 FIND v(dout1_15) AT=280.05n

.meas tran vdout1_16ck270 FIND v(dout1_16) AT=280.05n

.meas tran vdout1_17ck270 FIND v(dout1_17) AT=280.05n

.meas tran vdout1_18ck270 FIND v(dout1_18) AT=280.05n

.meas tran vdout1_19ck270 FIND v(dout1_19) AT=280.05n

.meas tran vdout1_0ck280 FIND v(dout1_0) AT=290.05n

.meas tran vdout1_1ck280 FIND v(dout1_1) AT=290.05n

.meas tran vdout1_2ck280 FIND v(dout1_2) AT=290.05n

.meas tran vdout1_3ck280 FIND v(dout1_3) AT=290.05n

.meas tran vdout1_4ck280 FIND v(dout1_4) AT=290.05n

.meas tran vdout1_5ck280 FIND v(dout1_5) AT=290.05n

.meas tran vdout1_6ck280 FIND v(dout1_6) AT=290.05n

.meas tran vdout1_7ck280 FIND v(dout1_7) AT=290.05n

.meas tran vdout1_8ck280 FIND v(dout1_8) AT=290.05n

.meas tran vdout1_9ck280 FIND v(dout1_9) AT=290.05n

.meas tran vdout1_10ck280 FIND v(dout1_10) AT=290.05n

.meas tran vdout1_11ck280 FIND v(dout1_11) AT=290.05n

.meas tran vdout1_12ck280 FIND v(dout1_12) AT=290.05n

.meas tran vdout1_13ck280 FIND v(dout1_13) AT=290.05n

.meas tran vdout1_14ck280 FIND v(dout1_14) AT=290.05n

.meas tran vdout1_15ck280 FIND v(dout1_15) AT=290.05n

.meas tran vdout1_16ck280 FIND v(dout1_16) AT=290.05n

.meas tran vdout1_17ck280 FIND v(dout1_17) AT=290.05n

.meas tran vdout1_18ck280 FIND v(dout1_18) AT=290.05n

.meas tran vdout1_19ck280 FIND v(dout1_19) AT=290.05n

.meas tran vdout1_0ck290 FIND v(dout1_0) AT=300.05n

.meas tran vdout1_1ck290 FIND v(dout1_1) AT=300.05n

.meas tran vdout1_2ck290 FIND v(dout1_2) AT=300.05n

.meas tran vdout1_3ck290 FIND v(dout1_3) AT=300.05n

.meas tran vdout1_4ck290 FIND v(dout1_4) AT=300.05n

.meas tran vdout1_5ck290 FIND v(dout1_5) AT=300.05n

.meas tran vdout1_6ck290 FIND v(dout1_6) AT=300.05n

.meas tran vdout1_7ck290 FIND v(dout1_7) AT=300.05n

.meas tran vdout1_8ck290 FIND v(dout1_8) AT=300.05n

.meas tran vdout1_9ck290 FIND v(dout1_9) AT=300.05n

.meas tran vdout1_10ck290 FIND v(dout1_10) AT=300.05n

.meas tran vdout1_11ck290 FIND v(dout1_11) AT=300.05n

.meas tran vdout1_12ck290 FIND v(dout1_12) AT=300.05n

.meas tran vdout1_13ck290 FIND v(dout1_13) AT=300.05n

.meas tran vdout1_14ck290 FIND v(dout1_14) AT=300.05n

.meas tran vdout1_15ck290 FIND v(dout1_15) AT=300.05n

.meas tran vdout1_16ck290 FIND v(dout1_16) AT=300.05n

.meas tran vdout1_17ck290 FIND v(dout1_17) AT=300.05n

.meas tran vdout1_18ck290 FIND v(dout1_18) AT=300.05n

.meas tran vdout1_19ck290 FIND v(dout1_19) AT=300.05n

.meas tran vdout1_0ck310 FIND v(dout1_0) AT=320.05n

.meas tran vdout1_1ck310 FIND v(dout1_1) AT=320.05n

.meas tran vdout1_2ck310 FIND v(dout1_2) AT=320.05n

.meas tran vdout1_3ck310 FIND v(dout1_3) AT=320.05n

.meas tran vdout1_4ck310 FIND v(dout1_4) AT=320.05n

.meas tran vdout1_5ck310 FIND v(dout1_5) AT=320.05n

.meas tran vdout1_6ck310 FIND v(dout1_6) AT=320.05n

.meas tran vdout1_7ck310 FIND v(dout1_7) AT=320.05n

.meas tran vdout1_8ck310 FIND v(dout1_8) AT=320.05n

.meas tran vdout1_9ck310 FIND v(dout1_9) AT=320.05n

.meas tran vdout1_10ck310 FIND v(dout1_10) AT=320.05n

.meas tran vdout1_11ck310 FIND v(dout1_11) AT=320.05n

.meas tran vdout1_12ck310 FIND v(dout1_12) AT=320.05n

.meas tran vdout1_13ck310 FIND v(dout1_13) AT=320.05n

.meas tran vdout1_14ck310 FIND v(dout1_14) AT=320.05n

.meas tran vdout1_15ck310 FIND v(dout1_15) AT=320.05n

.meas tran vdout1_16ck310 FIND v(dout1_16) AT=320.05n

.meas tran vdout1_17ck310 FIND v(dout1_17) AT=320.05n

.meas tran vdout1_18ck310 FIND v(dout1_18) AT=320.05n

.meas tran vdout1_19ck310 FIND v(dout1_19) AT=320.05n

.meas tran vdout1_0ck330 FIND v(dout1_0) AT=340.05n

.meas tran vdout1_1ck330 FIND v(dout1_1) AT=340.05n

.meas tran vdout1_2ck330 FIND v(dout1_2) AT=340.05n

.meas tran vdout1_3ck330 FIND v(dout1_3) AT=340.05n

.meas tran vdout1_4ck330 FIND v(dout1_4) AT=340.05n

.meas tran vdout1_5ck330 FIND v(dout1_5) AT=340.05n

.meas tran vdout1_6ck330 FIND v(dout1_6) AT=340.05n

.meas tran vdout1_7ck330 FIND v(dout1_7) AT=340.05n

.meas tran vdout1_8ck330 FIND v(dout1_8) AT=340.05n

.meas tran vdout1_9ck330 FIND v(dout1_9) AT=340.05n

.meas tran vdout1_10ck330 FIND v(dout1_10) AT=340.05n

.meas tran vdout1_11ck330 FIND v(dout1_11) AT=340.05n

.meas tran vdout1_12ck330 FIND v(dout1_12) AT=340.05n

.meas tran vdout1_13ck330 FIND v(dout1_13) AT=340.05n

.meas tran vdout1_14ck330 FIND v(dout1_14) AT=340.05n

.meas tran vdout1_15ck330 FIND v(dout1_15) AT=340.05n

.meas tran vdout1_16ck330 FIND v(dout1_16) AT=340.05n

.meas tran vdout1_17ck330 FIND v(dout1_17) AT=340.05n

.meas tran vdout1_18ck330 FIND v(dout1_18) AT=340.05n

.meas tran vdout1_19ck330 FIND v(dout1_19) AT=340.05n

.meas tran vdout1_0ck360 FIND v(dout1_0) AT=370.05n

.meas tran vdout1_1ck360 FIND v(dout1_1) AT=370.05n

.meas tran vdout1_2ck360 FIND v(dout1_2) AT=370.05n

.meas tran vdout1_3ck360 FIND v(dout1_3) AT=370.05n

.meas tran vdout1_4ck360 FIND v(dout1_4) AT=370.05n

.meas tran vdout1_5ck360 FIND v(dout1_5) AT=370.05n

.meas tran vdout1_6ck360 FIND v(dout1_6) AT=370.05n

.meas tran vdout1_7ck360 FIND v(dout1_7) AT=370.05n

.meas tran vdout1_8ck360 FIND v(dout1_8) AT=370.05n

.meas tran vdout1_9ck360 FIND v(dout1_9) AT=370.05n

.meas tran vdout1_10ck360 FIND v(dout1_10) AT=370.05n

.meas tran vdout1_11ck360 FIND v(dout1_11) AT=370.05n

.meas tran vdout1_12ck360 FIND v(dout1_12) AT=370.05n

.meas tran vdout1_13ck360 FIND v(dout1_13) AT=370.05n

.meas tran vdout1_14ck360 FIND v(dout1_14) AT=370.05n

.meas tran vdout1_15ck360 FIND v(dout1_15) AT=370.05n

.meas tran vdout1_16ck360 FIND v(dout1_16) AT=370.05n

.meas tran vdout1_17ck360 FIND v(dout1_17) AT=370.05n

.meas tran vdout1_18ck360 FIND v(dout1_18) AT=370.05n

.meas tran vdout1_19ck360 FIND v(dout1_19) AT=370.05n

.meas tran vdout1_0ck390 FIND v(dout1_0) AT=400.05n

.meas tran vdout1_1ck390 FIND v(dout1_1) AT=400.05n

.meas tran vdout1_2ck390 FIND v(dout1_2) AT=400.05n

.meas tran vdout1_3ck390 FIND v(dout1_3) AT=400.05n

.meas tran vdout1_4ck390 FIND v(dout1_4) AT=400.05n

.meas tran vdout1_5ck390 FIND v(dout1_5) AT=400.05n

.meas tran vdout1_6ck390 FIND v(dout1_6) AT=400.05n

.meas tran vdout1_7ck390 FIND v(dout1_7) AT=400.05n

.meas tran vdout1_8ck390 FIND v(dout1_8) AT=400.05n

.meas tran vdout1_9ck390 FIND v(dout1_9) AT=400.05n

.meas tran vdout1_10ck390 FIND v(dout1_10) AT=400.05n

.meas tran vdout1_11ck390 FIND v(dout1_11) AT=400.05n

.meas tran vdout1_12ck390 FIND v(dout1_12) AT=400.05n

.meas tran vdout1_13ck390 FIND v(dout1_13) AT=400.05n

.meas tran vdout1_14ck390 FIND v(dout1_14) AT=400.05n

.meas tran vdout1_15ck390 FIND v(dout1_15) AT=400.05n

.meas tran vdout1_16ck390 FIND v(dout1_16) AT=400.05n

.meas tran vdout1_17ck390 FIND v(dout1_17) AT=400.05n

.meas tran vdout1_18ck390 FIND v(dout1_18) AT=400.05n

.meas tran vdout1_19ck390 FIND v(dout1_19) AT=400.05n

.meas tran vdout1_0ck410 FIND v(dout1_0) AT=420.05n

.meas tran vdout1_1ck410 FIND v(dout1_1) AT=420.05n

.meas tran vdout1_2ck410 FIND v(dout1_2) AT=420.05n

.meas tran vdout1_3ck410 FIND v(dout1_3) AT=420.05n

.meas tran vdout1_4ck410 FIND v(dout1_4) AT=420.05n

.meas tran vdout1_5ck410 FIND v(dout1_5) AT=420.05n

.meas tran vdout1_6ck410 FIND v(dout1_6) AT=420.05n

.meas tran vdout1_7ck410 FIND v(dout1_7) AT=420.05n

.meas tran vdout1_8ck410 FIND v(dout1_8) AT=420.05n

.meas tran vdout1_9ck410 FIND v(dout1_9) AT=420.05n

.meas tran vdout1_10ck410 FIND v(dout1_10) AT=420.05n

.meas tran vdout1_11ck410 FIND v(dout1_11) AT=420.05n

.meas tran vdout1_12ck410 FIND v(dout1_12) AT=420.05n

.meas tran vdout1_13ck410 FIND v(dout1_13) AT=420.05n

.meas tran vdout1_14ck410 FIND v(dout1_14) AT=420.05n

.meas tran vdout1_15ck410 FIND v(dout1_15) AT=420.05n

.meas tran vdout1_16ck410 FIND v(dout1_16) AT=420.05n

.meas tran vdout1_17ck410 FIND v(dout1_17) AT=420.05n

.meas tran vdout1_18ck410 FIND v(dout1_18) AT=420.05n

.meas tran vdout1_19ck410 FIND v(dout1_19) AT=420.05n

.meas tran vdout1_0ck470 FIND v(dout1_0) AT=480.05n

.meas tran vdout1_1ck470 FIND v(dout1_1) AT=480.05n

.meas tran vdout1_2ck470 FIND v(dout1_2) AT=480.05n

.meas tran vdout1_3ck470 FIND v(dout1_3) AT=480.05n

.meas tran vdout1_4ck470 FIND v(dout1_4) AT=480.05n

.meas tran vdout1_5ck470 FIND v(dout1_5) AT=480.05n

.meas tran vdout1_6ck470 FIND v(dout1_6) AT=480.05n

.meas tran vdout1_7ck470 FIND v(dout1_7) AT=480.05n

.meas tran vdout1_8ck470 FIND v(dout1_8) AT=480.05n

.meas tran vdout1_9ck470 FIND v(dout1_9) AT=480.05n

.meas tran vdout1_10ck470 FIND v(dout1_10) AT=480.05n

.meas tran vdout1_11ck470 FIND v(dout1_11) AT=480.05n

.meas tran vdout1_12ck470 FIND v(dout1_12) AT=480.05n

.meas tran vdout1_13ck470 FIND v(dout1_13) AT=480.05n

.meas tran vdout1_14ck470 FIND v(dout1_14) AT=480.05n

.meas tran vdout1_15ck470 FIND v(dout1_15) AT=480.05n

.meas tran vdout1_16ck470 FIND v(dout1_16) AT=480.05n

.meas tran vdout1_17ck470 FIND v(dout1_17) AT=480.05n

.meas tran vdout1_18ck470 FIND v(dout1_18) AT=480.05n

.meas tran vdout1_19ck470 FIND v(dout1_19) AT=480.05n

.meas tran vdout1_0ck490 FIND v(dout1_0) AT=500.05n

.meas tran vdout1_1ck490 FIND v(dout1_1) AT=500.05n

.meas tran vdout1_2ck490 FIND v(dout1_2) AT=500.05n

.meas tran vdout1_3ck490 FIND v(dout1_3) AT=500.05n

.meas tran vdout1_4ck490 FIND v(dout1_4) AT=500.05n

.meas tran vdout1_5ck490 FIND v(dout1_5) AT=500.05n

.meas tran vdout1_6ck490 FIND v(dout1_6) AT=500.05n

.meas tran vdout1_7ck490 FIND v(dout1_7) AT=500.05n

.meas tran vdout1_8ck490 FIND v(dout1_8) AT=500.05n

.meas tran vdout1_9ck490 FIND v(dout1_9) AT=500.05n

.meas tran vdout1_10ck490 FIND v(dout1_10) AT=500.05n

.meas tran vdout1_11ck490 FIND v(dout1_11) AT=500.05n

.meas tran vdout1_12ck490 FIND v(dout1_12) AT=500.05n

.meas tran vdout1_13ck490 FIND v(dout1_13) AT=500.05n

.meas tran vdout1_14ck490 FIND v(dout1_14) AT=500.05n

.meas tran vdout1_15ck490 FIND v(dout1_15) AT=500.05n

.meas tran vdout1_16ck490 FIND v(dout1_16) AT=500.05n

.meas tran vdout1_17ck490 FIND v(dout1_17) AT=500.05n

.meas tran vdout1_18ck490 FIND v(dout1_18) AT=500.05n

.meas tran vdout1_19ck490 FIND v(dout1_19) AT=500.05n

.meas tran vdout1_0ck500 FIND v(dout1_0) AT=510.05n

.meas tran vdout1_1ck500 FIND v(dout1_1) AT=510.05n

.meas tran vdout1_2ck500 FIND v(dout1_2) AT=510.05n

.meas tran vdout1_3ck500 FIND v(dout1_3) AT=510.05n

.meas tran vdout1_4ck500 FIND v(dout1_4) AT=510.05n

.meas tran vdout1_5ck500 FIND v(dout1_5) AT=510.05n

.meas tran vdout1_6ck500 FIND v(dout1_6) AT=510.05n

.meas tran vdout1_7ck500 FIND v(dout1_7) AT=510.05n

.meas tran vdout1_8ck500 FIND v(dout1_8) AT=510.05n

.meas tran vdout1_9ck500 FIND v(dout1_9) AT=510.05n

.meas tran vdout1_10ck500 FIND v(dout1_10) AT=510.05n

.meas tran vdout1_11ck500 FIND v(dout1_11) AT=510.05n

.meas tran vdout1_12ck500 FIND v(dout1_12) AT=510.05n

.meas tran vdout1_13ck500 FIND v(dout1_13) AT=510.05n

.meas tran vdout1_14ck500 FIND v(dout1_14) AT=510.05n

.meas tran vdout1_15ck500 FIND v(dout1_15) AT=510.05n

.meas tran vdout1_16ck500 FIND v(dout1_16) AT=510.05n

.meas tran vdout1_17ck500 FIND v(dout1_17) AT=510.05n

.meas tran vdout1_18ck500 FIND v(dout1_18) AT=510.05n

.meas tran vdout1_19ck500 FIND v(dout1_19) AT=510.05n

.meas tran vdout1_0ck520 FIND v(dout1_0) AT=530.05n

.meas tran vdout1_1ck520 FIND v(dout1_1) AT=530.05n

.meas tran vdout1_2ck520 FIND v(dout1_2) AT=530.05n

.meas tran vdout1_3ck520 FIND v(dout1_3) AT=530.05n

.meas tran vdout1_4ck520 FIND v(dout1_4) AT=530.05n

.meas tran vdout1_5ck520 FIND v(dout1_5) AT=530.05n

.meas tran vdout1_6ck520 FIND v(dout1_6) AT=530.05n

.meas tran vdout1_7ck520 FIND v(dout1_7) AT=530.05n

.meas tran vdout1_8ck520 FIND v(dout1_8) AT=530.05n

.meas tran vdout1_9ck520 FIND v(dout1_9) AT=530.05n

.meas tran vdout1_10ck520 FIND v(dout1_10) AT=530.05n

.meas tran vdout1_11ck520 FIND v(dout1_11) AT=530.05n

.meas tran vdout1_12ck520 FIND v(dout1_12) AT=530.05n

.meas tran vdout1_13ck520 FIND v(dout1_13) AT=530.05n

.meas tran vdout1_14ck520 FIND v(dout1_14) AT=530.05n

.meas tran vdout1_15ck520 FIND v(dout1_15) AT=530.05n

.meas tran vdout1_16ck520 FIND v(dout1_16) AT=530.05n

.meas tran vdout1_17ck520 FIND v(dout1_17) AT=530.05n

.meas tran vdout1_18ck520 FIND v(dout1_18) AT=530.05n

.meas tran vdout1_19ck520 FIND v(dout1_19) AT=530.05n

.meas tran vdout1_0ck530 FIND v(dout1_0) AT=540.05n

.meas tran vdout1_1ck530 FIND v(dout1_1) AT=540.05n

.meas tran vdout1_2ck530 FIND v(dout1_2) AT=540.05n

.meas tran vdout1_3ck530 FIND v(dout1_3) AT=540.05n

.meas tran vdout1_4ck530 FIND v(dout1_4) AT=540.05n

.meas tran vdout1_5ck530 FIND v(dout1_5) AT=540.05n

.meas tran vdout1_6ck530 FIND v(dout1_6) AT=540.05n

.meas tran vdout1_7ck530 FIND v(dout1_7) AT=540.05n

.meas tran vdout1_8ck530 FIND v(dout1_8) AT=540.05n

.meas tran vdout1_9ck530 FIND v(dout1_9) AT=540.05n

.meas tran vdout1_10ck530 FIND v(dout1_10) AT=540.05n

.meas tran vdout1_11ck530 FIND v(dout1_11) AT=540.05n

.meas tran vdout1_12ck530 FIND v(dout1_12) AT=540.05n

.meas tran vdout1_13ck530 FIND v(dout1_13) AT=540.05n

.meas tran vdout1_14ck530 FIND v(dout1_14) AT=540.05n

.meas tran vdout1_15ck530 FIND v(dout1_15) AT=540.05n

.meas tran vdout1_16ck530 FIND v(dout1_16) AT=540.05n

.meas tran vdout1_17ck530 FIND v(dout1_17) AT=540.05n

.meas tran vdout1_18ck530 FIND v(dout1_18) AT=540.05n

.meas tran vdout1_19ck530 FIND v(dout1_19) AT=540.05n

.meas tran vdout1_0ck540 FIND v(dout1_0) AT=550.05n

.meas tran vdout1_1ck540 FIND v(dout1_1) AT=550.05n

.meas tran vdout1_2ck540 FIND v(dout1_2) AT=550.05n

.meas tran vdout1_3ck540 FIND v(dout1_3) AT=550.05n

.meas tran vdout1_4ck540 FIND v(dout1_4) AT=550.05n

.meas tran vdout1_5ck540 FIND v(dout1_5) AT=550.05n

.meas tran vdout1_6ck540 FIND v(dout1_6) AT=550.05n

.meas tran vdout1_7ck540 FIND v(dout1_7) AT=550.05n

.meas tran vdout1_8ck540 FIND v(dout1_8) AT=550.05n

.meas tran vdout1_9ck540 FIND v(dout1_9) AT=550.05n

.meas tran vdout1_10ck540 FIND v(dout1_10) AT=550.05n

.meas tran vdout1_11ck540 FIND v(dout1_11) AT=550.05n

.meas tran vdout1_12ck540 FIND v(dout1_12) AT=550.05n

.meas tran vdout1_13ck540 FIND v(dout1_13) AT=550.05n

.meas tran vdout1_14ck540 FIND v(dout1_14) AT=550.05n

.meas tran vdout1_15ck540 FIND v(dout1_15) AT=550.05n

.meas tran vdout1_16ck540 FIND v(dout1_16) AT=550.05n

.meas tran vdout1_17ck540 FIND v(dout1_17) AT=550.05n

.meas tran vdout1_18ck540 FIND v(dout1_18) AT=550.05n

.meas tran vdout1_19ck540 FIND v(dout1_19) AT=550.05n

.meas tran vdout1_0ck580 FIND v(dout1_0) AT=590.05n

.meas tran vdout1_1ck580 FIND v(dout1_1) AT=590.05n

.meas tran vdout1_2ck580 FIND v(dout1_2) AT=590.05n

.meas tran vdout1_3ck580 FIND v(dout1_3) AT=590.05n

.meas tran vdout1_4ck580 FIND v(dout1_4) AT=590.05n

.meas tran vdout1_5ck580 FIND v(dout1_5) AT=590.05n

.meas tran vdout1_6ck580 FIND v(dout1_6) AT=590.05n

.meas tran vdout1_7ck580 FIND v(dout1_7) AT=590.05n

.meas tran vdout1_8ck580 FIND v(dout1_8) AT=590.05n

.meas tran vdout1_9ck580 FIND v(dout1_9) AT=590.05n

.meas tran vdout1_10ck580 FIND v(dout1_10) AT=590.05n

.meas tran vdout1_11ck580 FIND v(dout1_11) AT=590.05n

.meas tran vdout1_12ck580 FIND v(dout1_12) AT=590.05n

.meas tran vdout1_13ck580 FIND v(dout1_13) AT=590.05n

.meas tran vdout1_14ck580 FIND v(dout1_14) AT=590.05n

.meas tran vdout1_15ck580 FIND v(dout1_15) AT=590.05n

.meas tran vdout1_16ck580 FIND v(dout1_16) AT=590.05n

.meas tran vdout1_17ck580 FIND v(dout1_17) AT=590.05n

.meas tran vdout1_18ck580 FIND v(dout1_18) AT=590.05n

.meas tran vdout1_19ck580 FIND v(dout1_19) AT=590.05n

.meas tran vdout1_0ck600 FIND v(dout1_0) AT=610.05n

.meas tran vdout1_1ck600 FIND v(dout1_1) AT=610.05n

.meas tran vdout1_2ck600 FIND v(dout1_2) AT=610.05n

.meas tran vdout1_3ck600 FIND v(dout1_3) AT=610.05n

.meas tran vdout1_4ck600 FIND v(dout1_4) AT=610.05n

.meas tran vdout1_5ck600 FIND v(dout1_5) AT=610.05n

.meas tran vdout1_6ck600 FIND v(dout1_6) AT=610.05n

.meas tran vdout1_7ck600 FIND v(dout1_7) AT=610.05n

.meas tran vdout1_8ck600 FIND v(dout1_8) AT=610.05n

.meas tran vdout1_9ck600 FIND v(dout1_9) AT=610.05n

.meas tran vdout1_10ck600 FIND v(dout1_10) AT=610.05n

.meas tran vdout1_11ck600 FIND v(dout1_11) AT=610.05n

.meas tran vdout1_12ck600 FIND v(dout1_12) AT=610.05n

.meas tran vdout1_13ck600 FIND v(dout1_13) AT=610.05n

.meas tran vdout1_14ck600 FIND v(dout1_14) AT=610.05n

.meas tran vdout1_15ck600 FIND v(dout1_15) AT=610.05n

.meas tran vdout1_16ck600 FIND v(dout1_16) AT=610.05n

.meas tran vdout1_17ck600 FIND v(dout1_17) AT=610.05n

.meas tran vdout1_18ck600 FIND v(dout1_18) AT=610.05n

.meas tran vdout1_19ck600 FIND v(dout1_19) AT=610.05n

.meas tran vdout1_0ck660 FIND v(dout1_0) AT=670.05n

.meas tran vdout1_1ck660 FIND v(dout1_1) AT=670.05n

.meas tran vdout1_2ck660 FIND v(dout1_2) AT=670.05n

.meas tran vdout1_3ck660 FIND v(dout1_3) AT=670.05n

.meas tran vdout1_4ck660 FIND v(dout1_4) AT=670.05n

.meas tran vdout1_5ck660 FIND v(dout1_5) AT=670.05n

.meas tran vdout1_6ck660 FIND v(dout1_6) AT=670.05n

.meas tran vdout1_7ck660 FIND v(dout1_7) AT=670.05n

.meas tran vdout1_8ck660 FIND v(dout1_8) AT=670.05n

.meas tran vdout1_9ck660 FIND v(dout1_9) AT=670.05n

.meas tran vdout1_10ck660 FIND v(dout1_10) AT=670.05n

.meas tran vdout1_11ck660 FIND v(dout1_11) AT=670.05n

.meas tran vdout1_12ck660 FIND v(dout1_12) AT=670.05n

.meas tran vdout1_13ck660 FIND v(dout1_13) AT=670.05n

.meas tran vdout1_14ck660 FIND v(dout1_14) AT=670.05n

.meas tran vdout1_15ck660 FIND v(dout1_15) AT=670.05n

.meas tran vdout1_16ck660 FIND v(dout1_16) AT=670.05n

.meas tran vdout1_17ck660 FIND v(dout1_17) AT=670.05n

.meas tran vdout1_18ck660 FIND v(dout1_18) AT=670.05n

.meas tran vdout1_19ck660 FIND v(dout1_19) AT=670.05n

.meas tran vdout1_0ck690 FIND v(dout1_0) AT=700.05n

.meas tran vdout1_1ck690 FIND v(dout1_1) AT=700.05n

.meas tran vdout1_2ck690 FIND v(dout1_2) AT=700.05n

.meas tran vdout1_3ck690 FIND v(dout1_3) AT=700.05n

.meas tran vdout1_4ck690 FIND v(dout1_4) AT=700.05n

.meas tran vdout1_5ck690 FIND v(dout1_5) AT=700.05n

.meas tran vdout1_6ck690 FIND v(dout1_6) AT=700.05n

.meas tran vdout1_7ck690 FIND v(dout1_7) AT=700.05n

.meas tran vdout1_8ck690 FIND v(dout1_8) AT=700.05n

.meas tran vdout1_9ck690 FIND v(dout1_9) AT=700.05n

.meas tran vdout1_10ck690 FIND v(dout1_10) AT=700.05n

.meas tran vdout1_11ck690 FIND v(dout1_11) AT=700.05n

.meas tran vdout1_12ck690 FIND v(dout1_12) AT=700.05n

.meas tran vdout1_13ck690 FIND v(dout1_13) AT=700.05n

.meas tran vdout1_14ck690 FIND v(dout1_14) AT=700.05n

.meas tran vdout1_15ck690 FIND v(dout1_15) AT=700.05n

.meas tran vdout1_16ck690 FIND v(dout1_16) AT=700.05n

.meas tran vdout1_17ck690 FIND v(dout1_17) AT=700.05n

.meas tran vdout1_18ck690 FIND v(dout1_18) AT=700.05n

.meas tran vdout1_19ck690 FIND v(dout1_19) AT=700.05n

.meas tran vdout1_0ck710 FIND v(dout1_0) AT=720.05n

.meas tran vdout1_1ck710 FIND v(dout1_1) AT=720.05n

.meas tran vdout1_2ck710 FIND v(dout1_2) AT=720.05n

.meas tran vdout1_3ck710 FIND v(dout1_3) AT=720.05n

.meas tran vdout1_4ck710 FIND v(dout1_4) AT=720.05n

.meas tran vdout1_5ck710 FIND v(dout1_5) AT=720.05n

.meas tran vdout1_6ck710 FIND v(dout1_6) AT=720.05n

.meas tran vdout1_7ck710 FIND v(dout1_7) AT=720.05n

.meas tran vdout1_8ck710 FIND v(dout1_8) AT=720.05n

.meas tran vdout1_9ck710 FIND v(dout1_9) AT=720.05n

.meas tran vdout1_10ck710 FIND v(dout1_10) AT=720.05n

.meas tran vdout1_11ck710 FIND v(dout1_11) AT=720.05n

.meas tran vdout1_12ck710 FIND v(dout1_12) AT=720.05n

.meas tran vdout1_13ck710 FIND v(dout1_13) AT=720.05n

.meas tran vdout1_14ck710 FIND v(dout1_14) AT=720.05n

.meas tran vdout1_15ck710 FIND v(dout1_15) AT=720.05n

.meas tran vdout1_16ck710 FIND v(dout1_16) AT=720.05n

.meas tran vdout1_17ck710 FIND v(dout1_17) AT=720.05n

.meas tran vdout1_18ck710 FIND v(dout1_18) AT=720.05n

.meas tran vdout1_19ck710 FIND v(dout1_19) AT=720.05n

.meas tran vdout1_0ck720 FIND v(dout1_0) AT=730.05n

.meas tran vdout1_1ck720 FIND v(dout1_1) AT=730.05n

.meas tran vdout1_2ck720 FIND v(dout1_2) AT=730.05n

.meas tran vdout1_3ck720 FIND v(dout1_3) AT=730.05n

.meas tran vdout1_4ck720 FIND v(dout1_4) AT=730.05n

.meas tran vdout1_5ck720 FIND v(dout1_5) AT=730.05n

.meas tran vdout1_6ck720 FIND v(dout1_6) AT=730.05n

.meas tran vdout1_7ck720 FIND v(dout1_7) AT=730.05n

.meas tran vdout1_8ck720 FIND v(dout1_8) AT=730.05n

.meas tran vdout1_9ck720 FIND v(dout1_9) AT=730.05n

.meas tran vdout1_10ck720 FIND v(dout1_10) AT=730.05n

.meas tran vdout1_11ck720 FIND v(dout1_11) AT=730.05n

.meas tran vdout1_12ck720 FIND v(dout1_12) AT=730.05n

.meas tran vdout1_13ck720 FIND v(dout1_13) AT=730.05n

.meas tran vdout1_14ck720 FIND v(dout1_14) AT=730.05n

.meas tran vdout1_15ck720 FIND v(dout1_15) AT=730.05n

.meas tran vdout1_16ck720 FIND v(dout1_16) AT=730.05n

.meas tran vdout1_17ck720 FIND v(dout1_17) AT=730.05n

.meas tran vdout1_18ck720 FIND v(dout1_18) AT=730.05n

.meas tran vdout1_19ck720 FIND v(dout1_19) AT=730.05n

.meas tran vdout1_0ck740 FIND v(dout1_0) AT=750.05n

.meas tran vdout1_1ck740 FIND v(dout1_1) AT=750.05n

.meas tran vdout1_2ck740 FIND v(dout1_2) AT=750.05n

.meas tran vdout1_3ck740 FIND v(dout1_3) AT=750.05n

.meas tran vdout1_4ck740 FIND v(dout1_4) AT=750.05n

.meas tran vdout1_5ck740 FIND v(dout1_5) AT=750.05n

.meas tran vdout1_6ck740 FIND v(dout1_6) AT=750.05n

.meas tran vdout1_7ck740 FIND v(dout1_7) AT=750.05n

.meas tran vdout1_8ck740 FIND v(dout1_8) AT=750.05n

.meas tran vdout1_9ck740 FIND v(dout1_9) AT=750.05n

.meas tran vdout1_10ck740 FIND v(dout1_10) AT=750.05n

.meas tran vdout1_11ck740 FIND v(dout1_11) AT=750.05n

.meas tran vdout1_12ck740 FIND v(dout1_12) AT=750.05n

.meas tran vdout1_13ck740 FIND v(dout1_13) AT=750.05n

.meas tran vdout1_14ck740 FIND v(dout1_14) AT=750.05n

.meas tran vdout1_15ck740 FIND v(dout1_15) AT=750.05n

.meas tran vdout1_16ck740 FIND v(dout1_16) AT=750.05n

.meas tran vdout1_17ck740 FIND v(dout1_17) AT=750.05n

.meas tran vdout1_18ck740 FIND v(dout1_18) AT=750.05n

.meas tran vdout1_19ck740 FIND v(dout1_19) AT=750.05n

.meas tran vdout1_0ck760 FIND v(dout1_0) AT=770.05n

.meas tran vdout1_1ck760 FIND v(dout1_1) AT=770.05n

.meas tran vdout1_2ck760 FIND v(dout1_2) AT=770.05n

.meas tran vdout1_3ck760 FIND v(dout1_3) AT=770.05n

.meas tran vdout1_4ck760 FIND v(dout1_4) AT=770.05n

.meas tran vdout1_5ck760 FIND v(dout1_5) AT=770.05n

.meas tran vdout1_6ck760 FIND v(dout1_6) AT=770.05n

.meas tran vdout1_7ck760 FIND v(dout1_7) AT=770.05n

.meas tran vdout1_8ck760 FIND v(dout1_8) AT=770.05n

.meas tran vdout1_9ck760 FIND v(dout1_9) AT=770.05n

.meas tran vdout1_10ck760 FIND v(dout1_10) AT=770.05n

.meas tran vdout1_11ck760 FIND v(dout1_11) AT=770.05n

.meas tran vdout1_12ck760 FIND v(dout1_12) AT=770.05n

.meas tran vdout1_13ck760 FIND v(dout1_13) AT=770.05n

.meas tran vdout1_14ck760 FIND v(dout1_14) AT=770.05n

.meas tran vdout1_15ck760 FIND v(dout1_15) AT=770.05n

.meas tran vdout1_16ck760 FIND v(dout1_16) AT=770.05n

.meas tran vdout1_17ck760 FIND v(dout1_17) AT=770.05n

.meas tran vdout1_18ck760 FIND v(dout1_18) AT=770.05n

.meas tran vdout1_19ck760 FIND v(dout1_19) AT=770.05n

.meas tran vdout1_0ck790 FIND v(dout1_0) AT=800.05n

.meas tran vdout1_1ck790 FIND v(dout1_1) AT=800.05n

.meas tran vdout1_2ck790 FIND v(dout1_2) AT=800.05n

.meas tran vdout1_3ck790 FIND v(dout1_3) AT=800.05n

.meas tran vdout1_4ck790 FIND v(dout1_4) AT=800.05n

.meas tran vdout1_5ck790 FIND v(dout1_5) AT=800.05n

.meas tran vdout1_6ck790 FIND v(dout1_6) AT=800.05n

.meas tran vdout1_7ck790 FIND v(dout1_7) AT=800.05n

.meas tran vdout1_8ck790 FIND v(dout1_8) AT=800.05n

.meas tran vdout1_9ck790 FIND v(dout1_9) AT=800.05n

.meas tran vdout1_10ck790 FIND v(dout1_10) AT=800.05n

.meas tran vdout1_11ck790 FIND v(dout1_11) AT=800.05n

.meas tran vdout1_12ck790 FIND v(dout1_12) AT=800.05n

.meas tran vdout1_13ck790 FIND v(dout1_13) AT=800.05n

.meas tran vdout1_14ck790 FIND v(dout1_14) AT=800.05n

.meas tran vdout1_15ck790 FIND v(dout1_15) AT=800.05n

.meas tran vdout1_16ck790 FIND v(dout1_16) AT=800.05n

.meas tran vdout1_17ck790 FIND v(dout1_17) AT=800.05n

.meas tran vdout1_18ck790 FIND v(dout1_18) AT=800.05n

.meas tran vdout1_19ck790 FIND v(dout1_19) AT=800.05n

.meas tran vdout1_0ck800 FIND v(dout1_0) AT=810.05n

.meas tran vdout1_1ck800 FIND v(dout1_1) AT=810.05n

.meas tran vdout1_2ck800 FIND v(dout1_2) AT=810.05n

.meas tran vdout1_3ck800 FIND v(dout1_3) AT=810.05n

.meas tran vdout1_4ck800 FIND v(dout1_4) AT=810.05n

.meas tran vdout1_5ck800 FIND v(dout1_5) AT=810.05n

.meas tran vdout1_6ck800 FIND v(dout1_6) AT=810.05n

.meas tran vdout1_7ck800 FIND v(dout1_7) AT=810.05n

.meas tran vdout1_8ck800 FIND v(dout1_8) AT=810.05n

.meas tran vdout1_9ck800 FIND v(dout1_9) AT=810.05n

.meas tran vdout1_10ck800 FIND v(dout1_10) AT=810.05n

.meas tran vdout1_11ck800 FIND v(dout1_11) AT=810.05n

.meas tran vdout1_12ck800 FIND v(dout1_12) AT=810.05n

.meas tran vdout1_13ck800 FIND v(dout1_13) AT=810.05n

.meas tran vdout1_14ck800 FIND v(dout1_14) AT=810.05n

.meas tran vdout1_15ck800 FIND v(dout1_15) AT=810.05n

.meas tran vdout1_16ck800 FIND v(dout1_16) AT=810.05n

.meas tran vdout1_17ck800 FIND v(dout1_17) AT=810.05n

.meas tran vdout1_18ck800 FIND v(dout1_18) AT=810.05n

.meas tran vdout1_19ck800 FIND v(dout1_19) AT=810.05n

.meas tran vdout1_0ck810 FIND v(dout1_0) AT=820.05n

.meas tran vdout1_1ck810 FIND v(dout1_1) AT=820.05n

.meas tran vdout1_2ck810 FIND v(dout1_2) AT=820.05n

.meas tran vdout1_3ck810 FIND v(dout1_3) AT=820.05n

.meas tran vdout1_4ck810 FIND v(dout1_4) AT=820.05n

.meas tran vdout1_5ck810 FIND v(dout1_5) AT=820.05n

.meas tran vdout1_6ck810 FIND v(dout1_6) AT=820.05n

.meas tran vdout1_7ck810 FIND v(dout1_7) AT=820.05n

.meas tran vdout1_8ck810 FIND v(dout1_8) AT=820.05n

.meas tran vdout1_9ck810 FIND v(dout1_9) AT=820.05n

.meas tran vdout1_10ck810 FIND v(dout1_10) AT=820.05n

.meas tran vdout1_11ck810 FIND v(dout1_11) AT=820.05n

.meas tran vdout1_12ck810 FIND v(dout1_12) AT=820.05n

.meas tran vdout1_13ck810 FIND v(dout1_13) AT=820.05n

.meas tran vdout1_14ck810 FIND v(dout1_14) AT=820.05n

.meas tran vdout1_15ck810 FIND v(dout1_15) AT=820.05n

.meas tran vdout1_16ck810 FIND v(dout1_16) AT=820.05n

.meas tran vdout1_17ck810 FIND v(dout1_17) AT=820.05n

.meas tran vdout1_18ck810 FIND v(dout1_18) AT=820.05n

.meas tran vdout1_19ck810 FIND v(dout1_19) AT=820.05n

.meas tran vdout1_0ck820 FIND v(dout1_0) AT=830.05n

.meas tran vdout1_1ck820 FIND v(dout1_1) AT=830.05n

.meas tran vdout1_2ck820 FIND v(dout1_2) AT=830.05n

.meas tran vdout1_3ck820 FIND v(dout1_3) AT=830.05n

.meas tran vdout1_4ck820 FIND v(dout1_4) AT=830.05n

.meas tran vdout1_5ck820 FIND v(dout1_5) AT=830.05n

.meas tran vdout1_6ck820 FIND v(dout1_6) AT=830.05n

.meas tran vdout1_7ck820 FIND v(dout1_7) AT=830.05n

.meas tran vdout1_8ck820 FIND v(dout1_8) AT=830.05n

.meas tran vdout1_9ck820 FIND v(dout1_9) AT=830.05n

.meas tran vdout1_10ck820 FIND v(dout1_10) AT=830.05n

.meas tran vdout1_11ck820 FIND v(dout1_11) AT=830.05n

.meas tran vdout1_12ck820 FIND v(dout1_12) AT=830.05n

.meas tran vdout1_13ck820 FIND v(dout1_13) AT=830.05n

.meas tran vdout1_14ck820 FIND v(dout1_14) AT=830.05n

.meas tran vdout1_15ck820 FIND v(dout1_15) AT=830.05n

.meas tran vdout1_16ck820 FIND v(dout1_16) AT=830.05n

.meas tran vdout1_17ck820 FIND v(dout1_17) AT=830.05n

.meas tran vdout1_18ck820 FIND v(dout1_18) AT=830.05n

.meas tran vdout1_19ck820 FIND v(dout1_19) AT=830.05n

.meas tran vdout1_0ck860 FIND v(dout1_0) AT=870.05n

.meas tran vdout1_1ck860 FIND v(dout1_1) AT=870.05n

.meas tran vdout1_2ck860 FIND v(dout1_2) AT=870.05n

.meas tran vdout1_3ck860 FIND v(dout1_3) AT=870.05n

.meas tran vdout1_4ck860 FIND v(dout1_4) AT=870.05n

.meas tran vdout1_5ck860 FIND v(dout1_5) AT=870.05n

.meas tran vdout1_6ck860 FIND v(dout1_6) AT=870.05n

.meas tran vdout1_7ck860 FIND v(dout1_7) AT=870.05n

.meas tran vdout1_8ck860 FIND v(dout1_8) AT=870.05n

.meas tran vdout1_9ck860 FIND v(dout1_9) AT=870.05n

.meas tran vdout1_10ck860 FIND v(dout1_10) AT=870.05n

.meas tran vdout1_11ck860 FIND v(dout1_11) AT=870.05n

.meas tran vdout1_12ck860 FIND v(dout1_12) AT=870.05n

.meas tran vdout1_13ck860 FIND v(dout1_13) AT=870.05n

.meas tran vdout1_14ck860 FIND v(dout1_14) AT=870.05n

.meas tran vdout1_15ck860 FIND v(dout1_15) AT=870.05n

.meas tran vdout1_16ck860 FIND v(dout1_16) AT=870.05n

.meas tran vdout1_17ck860 FIND v(dout1_17) AT=870.05n

.meas tran vdout1_18ck860 FIND v(dout1_18) AT=870.05n

.meas tran vdout1_19ck860 FIND v(dout1_19) AT=870.05n

.meas tran vdout1_0ck910 FIND v(dout1_0) AT=920.05n

.meas tran vdout1_1ck910 FIND v(dout1_1) AT=920.05n

.meas tran vdout1_2ck910 FIND v(dout1_2) AT=920.05n

.meas tran vdout1_3ck910 FIND v(dout1_3) AT=920.05n

.meas tran vdout1_4ck910 FIND v(dout1_4) AT=920.05n

.meas tran vdout1_5ck910 FIND v(dout1_5) AT=920.05n

.meas tran vdout1_6ck910 FIND v(dout1_6) AT=920.05n

.meas tran vdout1_7ck910 FIND v(dout1_7) AT=920.05n

.meas tran vdout1_8ck910 FIND v(dout1_8) AT=920.05n

.meas tran vdout1_9ck910 FIND v(dout1_9) AT=920.05n

.meas tran vdout1_10ck910 FIND v(dout1_10) AT=920.05n

.meas tran vdout1_11ck910 FIND v(dout1_11) AT=920.05n

.meas tran vdout1_12ck910 FIND v(dout1_12) AT=920.05n

.meas tran vdout1_13ck910 FIND v(dout1_13) AT=920.05n

.meas tran vdout1_14ck910 FIND v(dout1_14) AT=920.05n

.meas tran vdout1_15ck910 FIND v(dout1_15) AT=920.05n

.meas tran vdout1_16ck910 FIND v(dout1_16) AT=920.05n

.meas tran vdout1_17ck910 FIND v(dout1_17) AT=920.05n

.meas tran vdout1_18ck910 FIND v(dout1_18) AT=920.05n

.meas tran vdout1_19ck910 FIND v(dout1_19) AT=920.05n

.meas tran vdout1_0ck920 FIND v(dout1_0) AT=930.05n

.meas tran vdout1_1ck920 FIND v(dout1_1) AT=930.05n

.meas tran vdout1_2ck920 FIND v(dout1_2) AT=930.05n

.meas tran vdout1_3ck920 FIND v(dout1_3) AT=930.05n

.meas tran vdout1_4ck920 FIND v(dout1_4) AT=930.05n

.meas tran vdout1_5ck920 FIND v(dout1_5) AT=930.05n

.meas tran vdout1_6ck920 FIND v(dout1_6) AT=930.05n

.meas tran vdout1_7ck920 FIND v(dout1_7) AT=930.05n

.meas tran vdout1_8ck920 FIND v(dout1_8) AT=930.05n

.meas tran vdout1_9ck920 FIND v(dout1_9) AT=930.05n

.meas tran vdout1_10ck920 FIND v(dout1_10) AT=930.05n

.meas tran vdout1_11ck920 FIND v(dout1_11) AT=930.05n

.meas tran vdout1_12ck920 FIND v(dout1_12) AT=930.05n

.meas tran vdout1_13ck920 FIND v(dout1_13) AT=930.05n

.meas tran vdout1_14ck920 FIND v(dout1_14) AT=930.05n

.meas tran vdout1_15ck920 FIND v(dout1_15) AT=930.05n

.meas tran vdout1_16ck920 FIND v(dout1_16) AT=930.05n

.meas tran vdout1_17ck920 FIND v(dout1_17) AT=930.05n

.meas tran vdout1_18ck920 FIND v(dout1_18) AT=930.05n

.meas tran vdout1_19ck920 FIND v(dout1_19) AT=930.05n

.meas tran vdout1_0ck930 FIND v(dout1_0) AT=940.05n

.meas tran vdout1_1ck930 FIND v(dout1_1) AT=940.05n

.meas tran vdout1_2ck930 FIND v(dout1_2) AT=940.05n

.meas tran vdout1_3ck930 FIND v(dout1_3) AT=940.05n

.meas tran vdout1_4ck930 FIND v(dout1_4) AT=940.05n

.meas tran vdout1_5ck930 FIND v(dout1_5) AT=940.05n

.meas tran vdout1_6ck930 FIND v(dout1_6) AT=940.05n

.meas tran vdout1_7ck930 FIND v(dout1_7) AT=940.05n

.meas tran vdout1_8ck930 FIND v(dout1_8) AT=940.05n

.meas tran vdout1_9ck930 FIND v(dout1_9) AT=940.05n

.meas tran vdout1_10ck930 FIND v(dout1_10) AT=940.05n

.meas tran vdout1_11ck930 FIND v(dout1_11) AT=940.05n

.meas tran vdout1_12ck930 FIND v(dout1_12) AT=940.05n

.meas tran vdout1_13ck930 FIND v(dout1_13) AT=940.05n

.meas tran vdout1_14ck930 FIND v(dout1_14) AT=940.05n

.meas tran vdout1_15ck930 FIND v(dout1_15) AT=940.05n

.meas tran vdout1_16ck930 FIND v(dout1_16) AT=940.05n

.meas tran vdout1_17ck930 FIND v(dout1_17) AT=940.05n

.meas tran vdout1_18ck930 FIND v(dout1_18) AT=940.05n

.meas tran vdout1_19ck930 FIND v(dout1_19) AT=940.05n

.meas tran vdout1_0ck940 FIND v(dout1_0) AT=950.05n

.meas tran vdout1_1ck940 FIND v(dout1_1) AT=950.05n

.meas tran vdout1_2ck940 FIND v(dout1_2) AT=950.05n

.meas tran vdout1_3ck940 FIND v(dout1_3) AT=950.05n

.meas tran vdout1_4ck940 FIND v(dout1_4) AT=950.05n

.meas tran vdout1_5ck940 FIND v(dout1_5) AT=950.05n

.meas tran vdout1_6ck940 FIND v(dout1_6) AT=950.05n

.meas tran vdout1_7ck940 FIND v(dout1_7) AT=950.05n

.meas tran vdout1_8ck940 FIND v(dout1_8) AT=950.05n

.meas tran vdout1_9ck940 FIND v(dout1_9) AT=950.05n

.meas tran vdout1_10ck940 FIND v(dout1_10) AT=950.05n

.meas tran vdout1_11ck940 FIND v(dout1_11) AT=950.05n

.meas tran vdout1_12ck940 FIND v(dout1_12) AT=950.05n

.meas tran vdout1_13ck940 FIND v(dout1_13) AT=950.05n

.meas tran vdout1_14ck940 FIND v(dout1_14) AT=950.05n

.meas tran vdout1_15ck940 FIND v(dout1_15) AT=950.05n

.meas tran vdout1_16ck940 FIND v(dout1_16) AT=950.05n

.meas tran vdout1_17ck940 FIND v(dout1_17) AT=950.05n

.meas tran vdout1_18ck940 FIND v(dout1_18) AT=950.05n

.meas tran vdout1_19ck940 FIND v(dout1_19) AT=950.05n

.meas tran vdout1_0ck960 FIND v(dout1_0) AT=970.05n

.meas tran vdout1_1ck960 FIND v(dout1_1) AT=970.05n

.meas tran vdout1_2ck960 FIND v(dout1_2) AT=970.05n

.meas tran vdout1_3ck960 FIND v(dout1_3) AT=970.05n

.meas tran vdout1_4ck960 FIND v(dout1_4) AT=970.05n

.meas tran vdout1_5ck960 FIND v(dout1_5) AT=970.05n

.meas tran vdout1_6ck960 FIND v(dout1_6) AT=970.05n

.meas tran vdout1_7ck960 FIND v(dout1_7) AT=970.05n

.meas tran vdout1_8ck960 FIND v(dout1_8) AT=970.05n

.meas tran vdout1_9ck960 FIND v(dout1_9) AT=970.05n

.meas tran vdout1_10ck960 FIND v(dout1_10) AT=970.05n

.meas tran vdout1_11ck960 FIND v(dout1_11) AT=970.05n

.meas tran vdout1_12ck960 FIND v(dout1_12) AT=970.05n

.meas tran vdout1_13ck960 FIND v(dout1_13) AT=970.05n

.meas tran vdout1_14ck960 FIND v(dout1_14) AT=970.05n

.meas tran vdout1_15ck960 FIND v(dout1_15) AT=970.05n

.meas tran vdout1_16ck960 FIND v(dout1_16) AT=970.05n

.meas tran vdout1_17ck960 FIND v(dout1_17) AT=970.05n

.meas tran vdout1_18ck960 FIND v(dout1_18) AT=970.05n

.meas tran vdout1_19ck960 FIND v(dout1_19) AT=970.05n

.meas tran vdout1_0ck970 FIND v(dout1_0) AT=980.05n

.meas tran vdout1_1ck970 FIND v(dout1_1) AT=980.05n

.meas tran vdout1_2ck970 FIND v(dout1_2) AT=980.05n

.meas tran vdout1_3ck970 FIND v(dout1_3) AT=980.05n

.meas tran vdout1_4ck970 FIND v(dout1_4) AT=980.05n

.meas tran vdout1_5ck970 FIND v(dout1_5) AT=980.05n

.meas tran vdout1_6ck970 FIND v(dout1_6) AT=980.05n

.meas tran vdout1_7ck970 FIND v(dout1_7) AT=980.05n

.meas tran vdout1_8ck970 FIND v(dout1_8) AT=980.05n

.meas tran vdout1_9ck970 FIND v(dout1_9) AT=980.05n

.meas tran vdout1_10ck970 FIND v(dout1_10) AT=980.05n

.meas tran vdout1_11ck970 FIND v(dout1_11) AT=980.05n

.meas tran vdout1_12ck970 FIND v(dout1_12) AT=980.05n

.meas tran vdout1_13ck970 FIND v(dout1_13) AT=980.05n

.meas tran vdout1_14ck970 FIND v(dout1_14) AT=980.05n

.meas tran vdout1_15ck970 FIND v(dout1_15) AT=980.05n

.meas tran vdout1_16ck970 FIND v(dout1_16) AT=980.05n

.meas tran vdout1_17ck970 FIND v(dout1_17) AT=980.05n

.meas tran vdout1_18ck970 FIND v(dout1_18) AT=980.05n

.meas tran vdout1_19ck970 FIND v(dout1_19) AT=980.05n

.meas tran vdout1_0ck1030 FIND v(dout1_0) AT=1040.05n

.meas tran vdout1_1ck1030 FIND v(dout1_1) AT=1040.05n

.meas tran vdout1_2ck1030 FIND v(dout1_2) AT=1040.05n

.meas tran vdout1_3ck1030 FIND v(dout1_3) AT=1040.05n

.meas tran vdout1_4ck1030 FIND v(dout1_4) AT=1040.05n

.meas tran vdout1_5ck1030 FIND v(dout1_5) AT=1040.05n

.meas tran vdout1_6ck1030 FIND v(dout1_6) AT=1040.05n

.meas tran vdout1_7ck1030 FIND v(dout1_7) AT=1040.05n

.meas tran vdout1_8ck1030 FIND v(dout1_8) AT=1040.05n

.meas tran vdout1_9ck1030 FIND v(dout1_9) AT=1040.05n

.meas tran vdout1_10ck1030 FIND v(dout1_10) AT=1040.05n

.meas tran vdout1_11ck1030 FIND v(dout1_11) AT=1040.05n

.meas tran vdout1_12ck1030 FIND v(dout1_12) AT=1040.05n

.meas tran vdout1_13ck1030 FIND v(dout1_13) AT=1040.05n

.meas tran vdout1_14ck1030 FIND v(dout1_14) AT=1040.05n

.meas tran vdout1_15ck1030 FIND v(dout1_15) AT=1040.05n

.meas tran vdout1_16ck1030 FIND v(dout1_16) AT=1040.05n

.meas tran vdout1_17ck1030 FIND v(dout1_17) AT=1040.05n

.meas tran vdout1_18ck1030 FIND v(dout1_18) AT=1040.05n

.meas tran vdout1_19ck1030 FIND v(dout1_19) AT=1040.05n

.meas tran vdout1_0ck1040 FIND v(dout1_0) AT=1050.05n

.meas tran vdout1_1ck1040 FIND v(dout1_1) AT=1050.05n

.meas tran vdout1_2ck1040 FIND v(dout1_2) AT=1050.05n

.meas tran vdout1_3ck1040 FIND v(dout1_3) AT=1050.05n

.meas tran vdout1_4ck1040 FIND v(dout1_4) AT=1050.05n

.meas tran vdout1_5ck1040 FIND v(dout1_5) AT=1050.05n

.meas tran vdout1_6ck1040 FIND v(dout1_6) AT=1050.05n

.meas tran vdout1_7ck1040 FIND v(dout1_7) AT=1050.05n

.meas tran vdout1_8ck1040 FIND v(dout1_8) AT=1050.05n

.meas tran vdout1_9ck1040 FIND v(dout1_9) AT=1050.05n

.meas tran vdout1_10ck1040 FIND v(dout1_10) AT=1050.05n

.meas tran vdout1_11ck1040 FIND v(dout1_11) AT=1050.05n

.meas tran vdout1_12ck1040 FIND v(dout1_12) AT=1050.05n

.meas tran vdout1_13ck1040 FIND v(dout1_13) AT=1050.05n

.meas tran vdout1_14ck1040 FIND v(dout1_14) AT=1050.05n

.meas tran vdout1_15ck1040 FIND v(dout1_15) AT=1050.05n

.meas tran vdout1_16ck1040 FIND v(dout1_16) AT=1050.05n

.meas tran vdout1_17ck1040 FIND v(dout1_17) AT=1050.05n

.meas tran vdout1_18ck1040 FIND v(dout1_18) AT=1050.05n

.meas tran vdout1_19ck1040 FIND v(dout1_19) AT=1050.05n

.meas tran vdout1_0ck1070 FIND v(dout1_0) AT=1080.05n

.meas tran vdout1_1ck1070 FIND v(dout1_1) AT=1080.05n

.meas tran vdout1_2ck1070 FIND v(dout1_2) AT=1080.05n

.meas tran vdout1_3ck1070 FIND v(dout1_3) AT=1080.05n

.meas tran vdout1_4ck1070 FIND v(dout1_4) AT=1080.05n

.meas tran vdout1_5ck1070 FIND v(dout1_5) AT=1080.05n

.meas tran vdout1_6ck1070 FIND v(dout1_6) AT=1080.05n

.meas tran vdout1_7ck1070 FIND v(dout1_7) AT=1080.05n

.meas tran vdout1_8ck1070 FIND v(dout1_8) AT=1080.05n

.meas tran vdout1_9ck1070 FIND v(dout1_9) AT=1080.05n

.meas tran vdout1_10ck1070 FIND v(dout1_10) AT=1080.05n

.meas tran vdout1_11ck1070 FIND v(dout1_11) AT=1080.05n

.meas tran vdout1_12ck1070 FIND v(dout1_12) AT=1080.05n

.meas tran vdout1_13ck1070 FIND v(dout1_13) AT=1080.05n

.meas tran vdout1_14ck1070 FIND v(dout1_14) AT=1080.05n

.meas tran vdout1_15ck1070 FIND v(dout1_15) AT=1080.05n

.meas tran vdout1_16ck1070 FIND v(dout1_16) AT=1080.05n

.meas tran vdout1_17ck1070 FIND v(dout1_17) AT=1080.05n

.meas tran vdout1_18ck1070 FIND v(dout1_18) AT=1080.05n

.meas tran vdout1_19ck1070 FIND v(dout1_19) AT=1080.05n

.meas tran vdout1_0ck1080 FIND v(dout1_0) AT=1090.05n

.meas tran vdout1_1ck1080 FIND v(dout1_1) AT=1090.05n

.meas tran vdout1_2ck1080 FIND v(dout1_2) AT=1090.05n

.meas tran vdout1_3ck1080 FIND v(dout1_3) AT=1090.05n

.meas tran vdout1_4ck1080 FIND v(dout1_4) AT=1090.05n

.meas tran vdout1_5ck1080 FIND v(dout1_5) AT=1090.05n

.meas tran vdout1_6ck1080 FIND v(dout1_6) AT=1090.05n

.meas tran vdout1_7ck1080 FIND v(dout1_7) AT=1090.05n

.meas tran vdout1_8ck1080 FIND v(dout1_8) AT=1090.05n

.meas tran vdout1_9ck1080 FIND v(dout1_9) AT=1090.05n

.meas tran vdout1_10ck1080 FIND v(dout1_10) AT=1090.05n

.meas tran vdout1_11ck1080 FIND v(dout1_11) AT=1090.05n

.meas tran vdout1_12ck1080 FIND v(dout1_12) AT=1090.05n

.meas tran vdout1_13ck1080 FIND v(dout1_13) AT=1090.05n

.meas tran vdout1_14ck1080 FIND v(dout1_14) AT=1090.05n

.meas tran vdout1_15ck1080 FIND v(dout1_15) AT=1090.05n

.meas tran vdout1_16ck1080 FIND v(dout1_16) AT=1090.05n

.meas tran vdout1_17ck1080 FIND v(dout1_17) AT=1090.05n

.meas tran vdout1_18ck1080 FIND v(dout1_18) AT=1090.05n

.meas tran vdout1_19ck1080 FIND v(dout1_19) AT=1090.05n

.meas tran vdout1_0ck1100 FIND v(dout1_0) AT=1110.05n

.meas tran vdout1_1ck1100 FIND v(dout1_1) AT=1110.05n

.meas tran vdout1_2ck1100 FIND v(dout1_2) AT=1110.05n

.meas tran vdout1_3ck1100 FIND v(dout1_3) AT=1110.05n

.meas tran vdout1_4ck1100 FIND v(dout1_4) AT=1110.05n

.meas tran vdout1_5ck1100 FIND v(dout1_5) AT=1110.05n

.meas tran vdout1_6ck1100 FIND v(dout1_6) AT=1110.05n

.meas tran vdout1_7ck1100 FIND v(dout1_7) AT=1110.05n

.meas tran vdout1_8ck1100 FIND v(dout1_8) AT=1110.05n

.meas tran vdout1_9ck1100 FIND v(dout1_9) AT=1110.05n

.meas tran vdout1_10ck1100 FIND v(dout1_10) AT=1110.05n

.meas tran vdout1_11ck1100 FIND v(dout1_11) AT=1110.05n

.meas tran vdout1_12ck1100 FIND v(dout1_12) AT=1110.05n

.meas tran vdout1_13ck1100 FIND v(dout1_13) AT=1110.05n

.meas tran vdout1_14ck1100 FIND v(dout1_14) AT=1110.05n

.meas tran vdout1_15ck1100 FIND v(dout1_15) AT=1110.05n

.meas tran vdout1_16ck1100 FIND v(dout1_16) AT=1110.05n

.meas tran vdout1_17ck1100 FIND v(dout1_17) AT=1110.05n

.meas tran vdout1_18ck1100 FIND v(dout1_18) AT=1110.05n

.meas tran vdout1_19ck1100 FIND v(dout1_19) AT=1110.05n

.meas tran vdout1_0ck1110 FIND v(dout1_0) AT=1120.05n

.meas tran vdout1_1ck1110 FIND v(dout1_1) AT=1120.05n

.meas tran vdout1_2ck1110 FIND v(dout1_2) AT=1120.05n

.meas tran vdout1_3ck1110 FIND v(dout1_3) AT=1120.05n

.meas tran vdout1_4ck1110 FIND v(dout1_4) AT=1120.05n

.meas tran vdout1_5ck1110 FIND v(dout1_5) AT=1120.05n

.meas tran vdout1_6ck1110 FIND v(dout1_6) AT=1120.05n

.meas tran vdout1_7ck1110 FIND v(dout1_7) AT=1120.05n

.meas tran vdout1_8ck1110 FIND v(dout1_8) AT=1120.05n

.meas tran vdout1_9ck1110 FIND v(dout1_9) AT=1120.05n

.meas tran vdout1_10ck1110 FIND v(dout1_10) AT=1120.05n

.meas tran vdout1_11ck1110 FIND v(dout1_11) AT=1120.05n

.meas tran vdout1_12ck1110 FIND v(dout1_12) AT=1120.05n

.meas tran vdout1_13ck1110 FIND v(dout1_13) AT=1120.05n

.meas tran vdout1_14ck1110 FIND v(dout1_14) AT=1120.05n

.meas tran vdout1_15ck1110 FIND v(dout1_15) AT=1120.05n

.meas tran vdout1_16ck1110 FIND v(dout1_16) AT=1120.05n

.meas tran vdout1_17ck1110 FIND v(dout1_17) AT=1120.05n

.meas tran vdout1_18ck1110 FIND v(dout1_18) AT=1120.05n

.meas tran vdout1_19ck1110 FIND v(dout1_19) AT=1120.05n

.meas tran vdout1_0ck1120 FIND v(dout1_0) AT=1130.05n

.meas tran vdout1_1ck1120 FIND v(dout1_1) AT=1130.05n

.meas tran vdout1_2ck1120 FIND v(dout1_2) AT=1130.05n

.meas tran vdout1_3ck1120 FIND v(dout1_3) AT=1130.05n

.meas tran vdout1_4ck1120 FIND v(dout1_4) AT=1130.05n

.meas tran vdout1_5ck1120 FIND v(dout1_5) AT=1130.05n

.meas tran vdout1_6ck1120 FIND v(dout1_6) AT=1130.05n

.meas tran vdout1_7ck1120 FIND v(dout1_7) AT=1130.05n

.meas tran vdout1_8ck1120 FIND v(dout1_8) AT=1130.05n

.meas tran vdout1_9ck1120 FIND v(dout1_9) AT=1130.05n

.meas tran vdout1_10ck1120 FIND v(dout1_10) AT=1130.05n

.meas tran vdout1_11ck1120 FIND v(dout1_11) AT=1130.05n

.meas tran vdout1_12ck1120 FIND v(dout1_12) AT=1130.05n

.meas tran vdout1_13ck1120 FIND v(dout1_13) AT=1130.05n

.meas tran vdout1_14ck1120 FIND v(dout1_14) AT=1130.05n

.meas tran vdout1_15ck1120 FIND v(dout1_15) AT=1130.05n

.meas tran vdout1_16ck1120 FIND v(dout1_16) AT=1130.05n

.meas tran vdout1_17ck1120 FIND v(dout1_17) AT=1130.05n

.meas tran vdout1_18ck1120 FIND v(dout1_18) AT=1130.05n

.meas tran vdout1_19ck1120 FIND v(dout1_19) AT=1130.05n

.meas tran vdout1_0ck1140 FIND v(dout1_0) AT=1150.05n

.meas tran vdout1_1ck1140 FIND v(dout1_1) AT=1150.05n

.meas tran vdout1_2ck1140 FIND v(dout1_2) AT=1150.05n

.meas tran vdout1_3ck1140 FIND v(dout1_3) AT=1150.05n

.meas tran vdout1_4ck1140 FIND v(dout1_4) AT=1150.05n

.meas tran vdout1_5ck1140 FIND v(dout1_5) AT=1150.05n

.meas tran vdout1_6ck1140 FIND v(dout1_6) AT=1150.05n

.meas tran vdout1_7ck1140 FIND v(dout1_7) AT=1150.05n

.meas tran vdout1_8ck1140 FIND v(dout1_8) AT=1150.05n

.meas tran vdout1_9ck1140 FIND v(dout1_9) AT=1150.05n

.meas tran vdout1_10ck1140 FIND v(dout1_10) AT=1150.05n

.meas tran vdout1_11ck1140 FIND v(dout1_11) AT=1150.05n

.meas tran vdout1_12ck1140 FIND v(dout1_12) AT=1150.05n

.meas tran vdout1_13ck1140 FIND v(dout1_13) AT=1150.05n

.meas tran vdout1_14ck1140 FIND v(dout1_14) AT=1150.05n

.meas tran vdout1_15ck1140 FIND v(dout1_15) AT=1150.05n

.meas tran vdout1_16ck1140 FIND v(dout1_16) AT=1150.05n

.meas tran vdout1_17ck1140 FIND v(dout1_17) AT=1150.05n

.meas tran vdout1_18ck1140 FIND v(dout1_18) AT=1150.05n

.meas tran vdout1_19ck1140 FIND v(dout1_19) AT=1150.05n

.meas tran vdout1_0ck1180 FIND v(dout1_0) AT=1190.05n

.meas tran vdout1_1ck1180 FIND v(dout1_1) AT=1190.05n

.meas tran vdout1_2ck1180 FIND v(dout1_2) AT=1190.05n

.meas tran vdout1_3ck1180 FIND v(dout1_3) AT=1190.05n

.meas tran vdout1_4ck1180 FIND v(dout1_4) AT=1190.05n

.meas tran vdout1_5ck1180 FIND v(dout1_5) AT=1190.05n

.meas tran vdout1_6ck1180 FIND v(dout1_6) AT=1190.05n

.meas tran vdout1_7ck1180 FIND v(dout1_7) AT=1190.05n

.meas tran vdout1_8ck1180 FIND v(dout1_8) AT=1190.05n

.meas tran vdout1_9ck1180 FIND v(dout1_9) AT=1190.05n

.meas tran vdout1_10ck1180 FIND v(dout1_10) AT=1190.05n

.meas tran vdout1_11ck1180 FIND v(dout1_11) AT=1190.05n

.meas tran vdout1_12ck1180 FIND v(dout1_12) AT=1190.05n

.meas tran vdout1_13ck1180 FIND v(dout1_13) AT=1190.05n

.meas tran vdout1_14ck1180 FIND v(dout1_14) AT=1190.05n

.meas tran vdout1_15ck1180 FIND v(dout1_15) AT=1190.05n

.meas tran vdout1_16ck1180 FIND v(dout1_16) AT=1190.05n

.meas tran vdout1_17ck1180 FIND v(dout1_17) AT=1190.05n

.meas tran vdout1_18ck1180 FIND v(dout1_18) AT=1190.05n

.meas tran vdout1_19ck1180 FIND v(dout1_19) AT=1190.05n

.meas tran vdout1_0ck1210 FIND v(dout1_0) AT=1220.05n

.meas tran vdout1_1ck1210 FIND v(dout1_1) AT=1220.05n

.meas tran vdout1_2ck1210 FIND v(dout1_2) AT=1220.05n

.meas tran vdout1_3ck1210 FIND v(dout1_3) AT=1220.05n

.meas tran vdout1_4ck1210 FIND v(dout1_4) AT=1220.05n

.meas tran vdout1_5ck1210 FIND v(dout1_5) AT=1220.05n

.meas tran vdout1_6ck1210 FIND v(dout1_6) AT=1220.05n

.meas tran vdout1_7ck1210 FIND v(dout1_7) AT=1220.05n

.meas tran vdout1_8ck1210 FIND v(dout1_8) AT=1220.05n

.meas tran vdout1_9ck1210 FIND v(dout1_9) AT=1220.05n

.meas tran vdout1_10ck1210 FIND v(dout1_10) AT=1220.05n

.meas tran vdout1_11ck1210 FIND v(dout1_11) AT=1220.05n

.meas tran vdout1_12ck1210 FIND v(dout1_12) AT=1220.05n

.meas tran vdout1_13ck1210 FIND v(dout1_13) AT=1220.05n

.meas tran vdout1_14ck1210 FIND v(dout1_14) AT=1220.05n

.meas tran vdout1_15ck1210 FIND v(dout1_15) AT=1220.05n

.meas tran vdout1_16ck1210 FIND v(dout1_16) AT=1220.05n

.meas tran vdout1_17ck1210 FIND v(dout1_17) AT=1220.05n

.meas tran vdout1_18ck1210 FIND v(dout1_18) AT=1220.05n

.meas tran vdout1_19ck1210 FIND v(dout1_19) AT=1220.05n

.meas tran vdout1_0ck1220 FIND v(dout1_0) AT=1230.05n

.meas tran vdout1_1ck1220 FIND v(dout1_1) AT=1230.05n

.meas tran vdout1_2ck1220 FIND v(dout1_2) AT=1230.05n

.meas tran vdout1_3ck1220 FIND v(dout1_3) AT=1230.05n

.meas tran vdout1_4ck1220 FIND v(dout1_4) AT=1230.05n

.meas tran vdout1_5ck1220 FIND v(dout1_5) AT=1230.05n

.meas tran vdout1_6ck1220 FIND v(dout1_6) AT=1230.05n

.meas tran vdout1_7ck1220 FIND v(dout1_7) AT=1230.05n

.meas tran vdout1_8ck1220 FIND v(dout1_8) AT=1230.05n

.meas tran vdout1_9ck1220 FIND v(dout1_9) AT=1230.05n

.meas tran vdout1_10ck1220 FIND v(dout1_10) AT=1230.05n

.meas tran vdout1_11ck1220 FIND v(dout1_11) AT=1230.05n

.meas tran vdout1_12ck1220 FIND v(dout1_12) AT=1230.05n

.meas tran vdout1_13ck1220 FIND v(dout1_13) AT=1230.05n

.meas tran vdout1_14ck1220 FIND v(dout1_14) AT=1230.05n

.meas tran vdout1_15ck1220 FIND v(dout1_15) AT=1230.05n

.meas tran vdout1_16ck1220 FIND v(dout1_16) AT=1230.05n

.meas tran vdout1_17ck1220 FIND v(dout1_17) AT=1230.05n

.meas tran vdout1_18ck1220 FIND v(dout1_18) AT=1230.05n

.meas tran vdout1_19ck1220 FIND v(dout1_19) AT=1230.05n

.meas tran vdout1_0ck1230 FIND v(dout1_0) AT=1240.05n

.meas tran vdout1_1ck1230 FIND v(dout1_1) AT=1240.05n

.meas tran vdout1_2ck1230 FIND v(dout1_2) AT=1240.05n

.meas tran vdout1_3ck1230 FIND v(dout1_3) AT=1240.05n

.meas tran vdout1_4ck1230 FIND v(dout1_4) AT=1240.05n

.meas tran vdout1_5ck1230 FIND v(dout1_5) AT=1240.05n

.meas tran vdout1_6ck1230 FIND v(dout1_6) AT=1240.05n

.meas tran vdout1_7ck1230 FIND v(dout1_7) AT=1240.05n

.meas tran vdout1_8ck1230 FIND v(dout1_8) AT=1240.05n

.meas tran vdout1_9ck1230 FIND v(dout1_9) AT=1240.05n

.meas tran vdout1_10ck1230 FIND v(dout1_10) AT=1240.05n

.meas tran vdout1_11ck1230 FIND v(dout1_11) AT=1240.05n

.meas tran vdout1_12ck1230 FIND v(dout1_12) AT=1240.05n

.meas tran vdout1_13ck1230 FIND v(dout1_13) AT=1240.05n

.meas tran vdout1_14ck1230 FIND v(dout1_14) AT=1240.05n

.meas tran vdout1_15ck1230 FIND v(dout1_15) AT=1240.05n

.meas tran vdout1_16ck1230 FIND v(dout1_16) AT=1240.05n

.meas tran vdout1_17ck1230 FIND v(dout1_17) AT=1240.05n

.meas tran vdout1_18ck1230 FIND v(dout1_18) AT=1240.05n

.meas tran vdout1_19ck1230 FIND v(dout1_19) AT=1240.05n

.meas tran vdout1_0ck1260 FIND v(dout1_0) AT=1270.05n

.meas tran vdout1_1ck1260 FIND v(dout1_1) AT=1270.05n

.meas tran vdout1_2ck1260 FIND v(dout1_2) AT=1270.05n

.meas tran vdout1_3ck1260 FIND v(dout1_3) AT=1270.05n

.meas tran vdout1_4ck1260 FIND v(dout1_4) AT=1270.05n

.meas tran vdout1_5ck1260 FIND v(dout1_5) AT=1270.05n

.meas tran vdout1_6ck1260 FIND v(dout1_6) AT=1270.05n

.meas tran vdout1_7ck1260 FIND v(dout1_7) AT=1270.05n

.meas tran vdout1_8ck1260 FIND v(dout1_8) AT=1270.05n

.meas tran vdout1_9ck1260 FIND v(dout1_9) AT=1270.05n

.meas tran vdout1_10ck1260 FIND v(dout1_10) AT=1270.05n

.meas tran vdout1_11ck1260 FIND v(dout1_11) AT=1270.05n

.meas tran vdout1_12ck1260 FIND v(dout1_12) AT=1270.05n

.meas tran vdout1_13ck1260 FIND v(dout1_13) AT=1270.05n

.meas tran vdout1_14ck1260 FIND v(dout1_14) AT=1270.05n

.meas tran vdout1_15ck1260 FIND v(dout1_15) AT=1270.05n

.meas tran vdout1_16ck1260 FIND v(dout1_16) AT=1270.05n

.meas tran vdout1_17ck1260 FIND v(dout1_17) AT=1270.05n

.meas tran vdout1_18ck1260 FIND v(dout1_18) AT=1270.05n

.meas tran vdout1_19ck1260 FIND v(dout1_19) AT=1270.05n

.meas tran vdout1_0ck1280 FIND v(dout1_0) AT=1290.05n

.meas tran vdout1_1ck1280 FIND v(dout1_1) AT=1290.05n

.meas tran vdout1_2ck1280 FIND v(dout1_2) AT=1290.05n

.meas tran vdout1_3ck1280 FIND v(dout1_3) AT=1290.05n

.meas tran vdout1_4ck1280 FIND v(dout1_4) AT=1290.05n

.meas tran vdout1_5ck1280 FIND v(dout1_5) AT=1290.05n

.meas tran vdout1_6ck1280 FIND v(dout1_6) AT=1290.05n

.meas tran vdout1_7ck1280 FIND v(dout1_7) AT=1290.05n

.meas tran vdout1_8ck1280 FIND v(dout1_8) AT=1290.05n

.meas tran vdout1_9ck1280 FIND v(dout1_9) AT=1290.05n

.meas tran vdout1_10ck1280 FIND v(dout1_10) AT=1290.05n

.meas tran vdout1_11ck1280 FIND v(dout1_11) AT=1290.05n

.meas tran vdout1_12ck1280 FIND v(dout1_12) AT=1290.05n

.meas tran vdout1_13ck1280 FIND v(dout1_13) AT=1290.05n

.meas tran vdout1_14ck1280 FIND v(dout1_14) AT=1290.05n

.meas tran vdout1_15ck1280 FIND v(dout1_15) AT=1290.05n

.meas tran vdout1_16ck1280 FIND v(dout1_16) AT=1290.05n

.meas tran vdout1_17ck1280 FIND v(dout1_17) AT=1290.05n

.meas tran vdout1_18ck1280 FIND v(dout1_18) AT=1290.05n

.meas tran vdout1_19ck1280 FIND v(dout1_19) AT=1290.05n

.meas tran vdout1_0ck1360 FIND v(dout1_0) AT=1370.05n

.meas tran vdout1_1ck1360 FIND v(dout1_1) AT=1370.05n

.meas tran vdout1_2ck1360 FIND v(dout1_2) AT=1370.05n

.meas tran vdout1_3ck1360 FIND v(dout1_3) AT=1370.05n

.meas tran vdout1_4ck1360 FIND v(dout1_4) AT=1370.05n

.meas tran vdout1_5ck1360 FIND v(dout1_5) AT=1370.05n

.meas tran vdout1_6ck1360 FIND v(dout1_6) AT=1370.05n

.meas tran vdout1_7ck1360 FIND v(dout1_7) AT=1370.05n

.meas tran vdout1_8ck1360 FIND v(dout1_8) AT=1370.05n

.meas tran vdout1_9ck1360 FIND v(dout1_9) AT=1370.05n

.meas tran vdout1_10ck1360 FIND v(dout1_10) AT=1370.05n

.meas tran vdout1_11ck1360 FIND v(dout1_11) AT=1370.05n

.meas tran vdout1_12ck1360 FIND v(dout1_12) AT=1370.05n

.meas tran vdout1_13ck1360 FIND v(dout1_13) AT=1370.05n

.meas tran vdout1_14ck1360 FIND v(dout1_14) AT=1370.05n

.meas tran vdout1_15ck1360 FIND v(dout1_15) AT=1370.05n

.meas tran vdout1_16ck1360 FIND v(dout1_16) AT=1370.05n

.meas tran vdout1_17ck1360 FIND v(dout1_17) AT=1370.05n

.meas tran vdout1_18ck1360 FIND v(dout1_18) AT=1370.05n

.meas tran vdout1_19ck1360 FIND v(dout1_19) AT=1370.05n

.meas tran vdout1_0ck1410 FIND v(dout1_0) AT=1420.05n

.meas tran vdout1_1ck1410 FIND v(dout1_1) AT=1420.05n

.meas tran vdout1_2ck1410 FIND v(dout1_2) AT=1420.05n

.meas tran vdout1_3ck1410 FIND v(dout1_3) AT=1420.05n

.meas tran vdout1_4ck1410 FIND v(dout1_4) AT=1420.05n

.meas tran vdout1_5ck1410 FIND v(dout1_5) AT=1420.05n

.meas tran vdout1_6ck1410 FIND v(dout1_6) AT=1420.05n

.meas tran vdout1_7ck1410 FIND v(dout1_7) AT=1420.05n

.meas tran vdout1_8ck1410 FIND v(dout1_8) AT=1420.05n

.meas tran vdout1_9ck1410 FIND v(dout1_9) AT=1420.05n

.meas tran vdout1_10ck1410 FIND v(dout1_10) AT=1420.05n

.meas tran vdout1_11ck1410 FIND v(dout1_11) AT=1420.05n

.meas tran vdout1_12ck1410 FIND v(dout1_12) AT=1420.05n

.meas tran vdout1_13ck1410 FIND v(dout1_13) AT=1420.05n

.meas tran vdout1_14ck1410 FIND v(dout1_14) AT=1420.05n

.meas tran vdout1_15ck1410 FIND v(dout1_15) AT=1420.05n

.meas tran vdout1_16ck1410 FIND v(dout1_16) AT=1420.05n

.meas tran vdout1_17ck1410 FIND v(dout1_17) AT=1420.05n

.meas tran vdout1_18ck1410 FIND v(dout1_18) AT=1420.05n

.meas tran vdout1_19ck1410 FIND v(dout1_19) AT=1420.05n

.meas tran vdout1_0ck1440 FIND v(dout1_0) AT=1450.05n

.meas tran vdout1_1ck1440 FIND v(dout1_1) AT=1450.05n

.meas tran vdout1_2ck1440 FIND v(dout1_2) AT=1450.05n

.meas tran vdout1_3ck1440 FIND v(dout1_3) AT=1450.05n

.meas tran vdout1_4ck1440 FIND v(dout1_4) AT=1450.05n

.meas tran vdout1_5ck1440 FIND v(dout1_5) AT=1450.05n

.meas tran vdout1_6ck1440 FIND v(dout1_6) AT=1450.05n

.meas tran vdout1_7ck1440 FIND v(dout1_7) AT=1450.05n

.meas tran vdout1_8ck1440 FIND v(dout1_8) AT=1450.05n

.meas tran vdout1_9ck1440 FIND v(dout1_9) AT=1450.05n

.meas tran vdout1_10ck1440 FIND v(dout1_10) AT=1450.05n

.meas tran vdout1_11ck1440 FIND v(dout1_11) AT=1450.05n

.meas tran vdout1_12ck1440 FIND v(dout1_12) AT=1450.05n

.meas tran vdout1_13ck1440 FIND v(dout1_13) AT=1450.05n

.meas tran vdout1_14ck1440 FIND v(dout1_14) AT=1450.05n

.meas tran vdout1_15ck1440 FIND v(dout1_15) AT=1450.05n

.meas tran vdout1_16ck1440 FIND v(dout1_16) AT=1450.05n

.meas tran vdout1_17ck1440 FIND v(dout1_17) AT=1450.05n

.meas tran vdout1_18ck1440 FIND v(dout1_18) AT=1450.05n

.meas tran vdout1_19ck1440 FIND v(dout1_19) AT=1450.05n

.meas tran vdout1_0ck1470 FIND v(dout1_0) AT=1480.05n

.meas tran vdout1_1ck1470 FIND v(dout1_1) AT=1480.05n

.meas tran vdout1_2ck1470 FIND v(dout1_2) AT=1480.05n

.meas tran vdout1_3ck1470 FIND v(dout1_3) AT=1480.05n

.meas tran vdout1_4ck1470 FIND v(dout1_4) AT=1480.05n

.meas tran vdout1_5ck1470 FIND v(dout1_5) AT=1480.05n

.meas tran vdout1_6ck1470 FIND v(dout1_6) AT=1480.05n

.meas tran vdout1_7ck1470 FIND v(dout1_7) AT=1480.05n

.meas tran vdout1_8ck1470 FIND v(dout1_8) AT=1480.05n

.meas tran vdout1_9ck1470 FIND v(dout1_9) AT=1480.05n

.meas tran vdout1_10ck1470 FIND v(dout1_10) AT=1480.05n

.meas tran vdout1_11ck1470 FIND v(dout1_11) AT=1480.05n

.meas tran vdout1_12ck1470 FIND v(dout1_12) AT=1480.05n

.meas tran vdout1_13ck1470 FIND v(dout1_13) AT=1480.05n

.meas tran vdout1_14ck1470 FIND v(dout1_14) AT=1480.05n

.meas tran vdout1_15ck1470 FIND v(dout1_15) AT=1480.05n

.meas tran vdout1_16ck1470 FIND v(dout1_16) AT=1480.05n

.meas tran vdout1_17ck1470 FIND v(dout1_17) AT=1480.05n

.meas tran vdout1_18ck1470 FIND v(dout1_18) AT=1480.05n

.meas tran vdout1_19ck1470 FIND v(dout1_19) AT=1480.05n

.meas tran vdout1_0ck1490 FIND v(dout1_0) AT=1500.05n

.meas tran vdout1_1ck1490 FIND v(dout1_1) AT=1500.05n

.meas tran vdout1_2ck1490 FIND v(dout1_2) AT=1500.05n

.meas tran vdout1_3ck1490 FIND v(dout1_3) AT=1500.05n

.meas tran vdout1_4ck1490 FIND v(dout1_4) AT=1500.05n

.meas tran vdout1_5ck1490 FIND v(dout1_5) AT=1500.05n

.meas tran vdout1_6ck1490 FIND v(dout1_6) AT=1500.05n

.meas tran vdout1_7ck1490 FIND v(dout1_7) AT=1500.05n

.meas tran vdout1_8ck1490 FIND v(dout1_8) AT=1500.05n

.meas tran vdout1_9ck1490 FIND v(dout1_9) AT=1500.05n

.meas tran vdout1_10ck1490 FIND v(dout1_10) AT=1500.05n

.meas tran vdout1_11ck1490 FIND v(dout1_11) AT=1500.05n

.meas tran vdout1_12ck1490 FIND v(dout1_12) AT=1500.05n

.meas tran vdout1_13ck1490 FIND v(dout1_13) AT=1500.05n

.meas tran vdout1_14ck1490 FIND v(dout1_14) AT=1500.05n

.meas tran vdout1_15ck1490 FIND v(dout1_15) AT=1500.05n

.meas tran vdout1_16ck1490 FIND v(dout1_16) AT=1500.05n

.meas tran vdout1_17ck1490 FIND v(dout1_17) AT=1500.05n

.meas tran vdout1_18ck1490 FIND v(dout1_18) AT=1500.05n

.meas tran vdout1_19ck1490 FIND v(dout1_19) AT=1500.05n

.meas tran vdout1_0ck1520 FIND v(dout1_0) AT=1530.05n

.meas tran vdout1_1ck1520 FIND v(dout1_1) AT=1530.05n

.meas tran vdout1_2ck1520 FIND v(dout1_2) AT=1530.05n

.meas tran vdout1_3ck1520 FIND v(dout1_3) AT=1530.05n

.meas tran vdout1_4ck1520 FIND v(dout1_4) AT=1530.05n

.meas tran vdout1_5ck1520 FIND v(dout1_5) AT=1530.05n

.meas tran vdout1_6ck1520 FIND v(dout1_6) AT=1530.05n

.meas tran vdout1_7ck1520 FIND v(dout1_7) AT=1530.05n

.meas tran vdout1_8ck1520 FIND v(dout1_8) AT=1530.05n

.meas tran vdout1_9ck1520 FIND v(dout1_9) AT=1530.05n

.meas tran vdout1_10ck1520 FIND v(dout1_10) AT=1530.05n

.meas tran vdout1_11ck1520 FIND v(dout1_11) AT=1530.05n

.meas tran vdout1_12ck1520 FIND v(dout1_12) AT=1530.05n

.meas tran vdout1_13ck1520 FIND v(dout1_13) AT=1530.05n

.meas tran vdout1_14ck1520 FIND v(dout1_14) AT=1530.05n

.meas tran vdout1_15ck1520 FIND v(dout1_15) AT=1530.05n

.meas tran vdout1_16ck1520 FIND v(dout1_16) AT=1530.05n

.meas tran vdout1_17ck1520 FIND v(dout1_17) AT=1530.05n

.meas tran vdout1_18ck1520 FIND v(dout1_18) AT=1530.05n

.meas tran vdout1_19ck1520 FIND v(dout1_19) AT=1530.05n

.meas tran vdout1_0ck1530 FIND v(dout1_0) AT=1540.05n

.meas tran vdout1_1ck1530 FIND v(dout1_1) AT=1540.05n

.meas tran vdout1_2ck1530 FIND v(dout1_2) AT=1540.05n

.meas tran vdout1_3ck1530 FIND v(dout1_3) AT=1540.05n

.meas tran vdout1_4ck1530 FIND v(dout1_4) AT=1540.05n

.meas tran vdout1_5ck1530 FIND v(dout1_5) AT=1540.05n

.meas tran vdout1_6ck1530 FIND v(dout1_6) AT=1540.05n

.meas tran vdout1_7ck1530 FIND v(dout1_7) AT=1540.05n

.meas tran vdout1_8ck1530 FIND v(dout1_8) AT=1540.05n

.meas tran vdout1_9ck1530 FIND v(dout1_9) AT=1540.05n

.meas tran vdout1_10ck1530 FIND v(dout1_10) AT=1540.05n

.meas tran vdout1_11ck1530 FIND v(dout1_11) AT=1540.05n

.meas tran vdout1_12ck1530 FIND v(dout1_12) AT=1540.05n

.meas tran vdout1_13ck1530 FIND v(dout1_13) AT=1540.05n

.meas tran vdout1_14ck1530 FIND v(dout1_14) AT=1540.05n

.meas tran vdout1_15ck1530 FIND v(dout1_15) AT=1540.05n

.meas tran vdout1_16ck1530 FIND v(dout1_16) AT=1540.05n

.meas tran vdout1_17ck1530 FIND v(dout1_17) AT=1540.05n

.meas tran vdout1_18ck1530 FIND v(dout1_18) AT=1540.05n

.meas tran vdout1_19ck1530 FIND v(dout1_19) AT=1540.05n

.meas tran vdout1_0ck1570 FIND v(dout1_0) AT=1580.05n

.meas tran vdout1_1ck1570 FIND v(dout1_1) AT=1580.05n

.meas tran vdout1_2ck1570 FIND v(dout1_2) AT=1580.05n

.meas tran vdout1_3ck1570 FIND v(dout1_3) AT=1580.05n

.meas tran vdout1_4ck1570 FIND v(dout1_4) AT=1580.05n

.meas tran vdout1_5ck1570 FIND v(dout1_5) AT=1580.05n

.meas tran vdout1_6ck1570 FIND v(dout1_6) AT=1580.05n

.meas tran vdout1_7ck1570 FIND v(dout1_7) AT=1580.05n

.meas tran vdout1_8ck1570 FIND v(dout1_8) AT=1580.05n

.meas tran vdout1_9ck1570 FIND v(dout1_9) AT=1580.05n

.meas tran vdout1_10ck1570 FIND v(dout1_10) AT=1580.05n

.meas tran vdout1_11ck1570 FIND v(dout1_11) AT=1580.05n

.meas tran vdout1_12ck1570 FIND v(dout1_12) AT=1580.05n

.meas tran vdout1_13ck1570 FIND v(dout1_13) AT=1580.05n

.meas tran vdout1_14ck1570 FIND v(dout1_14) AT=1580.05n

.meas tran vdout1_15ck1570 FIND v(dout1_15) AT=1580.05n

.meas tran vdout1_16ck1570 FIND v(dout1_16) AT=1580.05n

.meas tran vdout1_17ck1570 FIND v(dout1_17) AT=1580.05n

.meas tran vdout1_18ck1570 FIND v(dout1_18) AT=1580.05n

.meas tran vdout1_19ck1570 FIND v(dout1_19) AT=1580.05n

.meas tran vdout1_0ck1590 FIND v(dout1_0) AT=1600.05n

.meas tran vdout1_1ck1590 FIND v(dout1_1) AT=1600.05n

.meas tran vdout1_2ck1590 FIND v(dout1_2) AT=1600.05n

.meas tran vdout1_3ck1590 FIND v(dout1_3) AT=1600.05n

.meas tran vdout1_4ck1590 FIND v(dout1_4) AT=1600.05n

.meas tran vdout1_5ck1590 FIND v(dout1_5) AT=1600.05n

.meas tran vdout1_6ck1590 FIND v(dout1_6) AT=1600.05n

.meas tran vdout1_7ck1590 FIND v(dout1_7) AT=1600.05n

.meas tran vdout1_8ck1590 FIND v(dout1_8) AT=1600.05n

.meas tran vdout1_9ck1590 FIND v(dout1_9) AT=1600.05n

.meas tran vdout1_10ck1590 FIND v(dout1_10) AT=1600.05n

.meas tran vdout1_11ck1590 FIND v(dout1_11) AT=1600.05n

.meas tran vdout1_12ck1590 FIND v(dout1_12) AT=1600.05n

.meas tran vdout1_13ck1590 FIND v(dout1_13) AT=1600.05n

.meas tran vdout1_14ck1590 FIND v(dout1_14) AT=1600.05n

.meas tran vdout1_15ck1590 FIND v(dout1_15) AT=1600.05n

.meas tran vdout1_16ck1590 FIND v(dout1_16) AT=1600.05n

.meas tran vdout1_17ck1590 FIND v(dout1_17) AT=1600.05n

.meas tran vdout1_18ck1590 FIND v(dout1_18) AT=1600.05n

.meas tran vdout1_19ck1590 FIND v(dout1_19) AT=1600.05n

.meas tran vdout1_0ck1620 FIND v(dout1_0) AT=1630.05n

.meas tran vdout1_1ck1620 FIND v(dout1_1) AT=1630.05n

.meas tran vdout1_2ck1620 FIND v(dout1_2) AT=1630.05n

.meas tran vdout1_3ck1620 FIND v(dout1_3) AT=1630.05n

.meas tran vdout1_4ck1620 FIND v(dout1_4) AT=1630.05n

.meas tran vdout1_5ck1620 FIND v(dout1_5) AT=1630.05n

.meas tran vdout1_6ck1620 FIND v(dout1_6) AT=1630.05n

.meas tran vdout1_7ck1620 FIND v(dout1_7) AT=1630.05n

.meas tran vdout1_8ck1620 FIND v(dout1_8) AT=1630.05n

.meas tran vdout1_9ck1620 FIND v(dout1_9) AT=1630.05n

.meas tran vdout1_10ck1620 FIND v(dout1_10) AT=1630.05n

.meas tran vdout1_11ck1620 FIND v(dout1_11) AT=1630.05n

.meas tran vdout1_12ck1620 FIND v(dout1_12) AT=1630.05n

.meas tran vdout1_13ck1620 FIND v(dout1_13) AT=1630.05n

.meas tran vdout1_14ck1620 FIND v(dout1_14) AT=1630.05n

.meas tran vdout1_15ck1620 FIND v(dout1_15) AT=1630.05n

.meas tran vdout1_16ck1620 FIND v(dout1_16) AT=1630.05n

.meas tran vdout1_17ck1620 FIND v(dout1_17) AT=1630.05n

.meas tran vdout1_18ck1620 FIND v(dout1_18) AT=1630.05n

.meas tran vdout1_19ck1620 FIND v(dout1_19) AT=1630.05n

.meas tran vdout1_0ck1670 FIND v(dout1_0) AT=1680.05n

.meas tran vdout1_1ck1670 FIND v(dout1_1) AT=1680.05n

.meas tran vdout1_2ck1670 FIND v(dout1_2) AT=1680.05n

.meas tran vdout1_3ck1670 FIND v(dout1_3) AT=1680.05n

.meas tran vdout1_4ck1670 FIND v(dout1_4) AT=1680.05n

.meas tran vdout1_5ck1670 FIND v(dout1_5) AT=1680.05n

.meas tran vdout1_6ck1670 FIND v(dout1_6) AT=1680.05n

.meas tran vdout1_7ck1670 FIND v(dout1_7) AT=1680.05n

.meas tran vdout1_8ck1670 FIND v(dout1_8) AT=1680.05n

.meas tran vdout1_9ck1670 FIND v(dout1_9) AT=1680.05n

.meas tran vdout1_10ck1670 FIND v(dout1_10) AT=1680.05n

.meas tran vdout1_11ck1670 FIND v(dout1_11) AT=1680.05n

.meas tran vdout1_12ck1670 FIND v(dout1_12) AT=1680.05n

.meas tran vdout1_13ck1670 FIND v(dout1_13) AT=1680.05n

.meas tran vdout1_14ck1670 FIND v(dout1_14) AT=1680.05n

.meas tran vdout1_15ck1670 FIND v(dout1_15) AT=1680.05n

.meas tran vdout1_16ck1670 FIND v(dout1_16) AT=1680.05n

.meas tran vdout1_17ck1670 FIND v(dout1_17) AT=1680.05n

.meas tran vdout1_18ck1670 FIND v(dout1_18) AT=1680.05n

.meas tran vdout1_19ck1670 FIND v(dout1_19) AT=1680.05n

.meas tran vdout1_0ck1700 FIND v(dout1_0) AT=1710.05n

.meas tran vdout1_1ck1700 FIND v(dout1_1) AT=1710.05n

.meas tran vdout1_2ck1700 FIND v(dout1_2) AT=1710.05n

.meas tran vdout1_3ck1700 FIND v(dout1_3) AT=1710.05n

.meas tran vdout1_4ck1700 FIND v(dout1_4) AT=1710.05n

.meas tran vdout1_5ck1700 FIND v(dout1_5) AT=1710.05n

.meas tran vdout1_6ck1700 FIND v(dout1_6) AT=1710.05n

.meas tran vdout1_7ck1700 FIND v(dout1_7) AT=1710.05n

.meas tran vdout1_8ck1700 FIND v(dout1_8) AT=1710.05n

.meas tran vdout1_9ck1700 FIND v(dout1_9) AT=1710.05n

.meas tran vdout1_10ck1700 FIND v(dout1_10) AT=1710.05n

.meas tran vdout1_11ck1700 FIND v(dout1_11) AT=1710.05n

.meas tran vdout1_12ck1700 FIND v(dout1_12) AT=1710.05n

.meas tran vdout1_13ck1700 FIND v(dout1_13) AT=1710.05n

.meas tran vdout1_14ck1700 FIND v(dout1_14) AT=1710.05n

.meas tran vdout1_15ck1700 FIND v(dout1_15) AT=1710.05n

.meas tran vdout1_16ck1700 FIND v(dout1_16) AT=1710.05n

.meas tran vdout1_17ck1700 FIND v(dout1_17) AT=1710.05n

.meas tran vdout1_18ck1700 FIND v(dout1_18) AT=1710.05n

.meas tran vdout1_19ck1700 FIND v(dout1_19) AT=1710.05n

.meas tran vdout1_0ck1710 FIND v(dout1_0) AT=1720.05n

.meas tran vdout1_1ck1710 FIND v(dout1_1) AT=1720.05n

.meas tran vdout1_2ck1710 FIND v(dout1_2) AT=1720.05n

.meas tran vdout1_3ck1710 FIND v(dout1_3) AT=1720.05n

.meas tran vdout1_4ck1710 FIND v(dout1_4) AT=1720.05n

.meas tran vdout1_5ck1710 FIND v(dout1_5) AT=1720.05n

.meas tran vdout1_6ck1710 FIND v(dout1_6) AT=1720.05n

.meas tran vdout1_7ck1710 FIND v(dout1_7) AT=1720.05n

.meas tran vdout1_8ck1710 FIND v(dout1_8) AT=1720.05n

.meas tran vdout1_9ck1710 FIND v(dout1_9) AT=1720.05n

.meas tran vdout1_10ck1710 FIND v(dout1_10) AT=1720.05n

.meas tran vdout1_11ck1710 FIND v(dout1_11) AT=1720.05n

.meas tran vdout1_12ck1710 FIND v(dout1_12) AT=1720.05n

.meas tran vdout1_13ck1710 FIND v(dout1_13) AT=1720.05n

.meas tran vdout1_14ck1710 FIND v(dout1_14) AT=1720.05n

.meas tran vdout1_15ck1710 FIND v(dout1_15) AT=1720.05n

.meas tran vdout1_16ck1710 FIND v(dout1_16) AT=1720.05n

.meas tran vdout1_17ck1710 FIND v(dout1_17) AT=1720.05n

.meas tran vdout1_18ck1710 FIND v(dout1_18) AT=1720.05n

.meas tran vdout1_19ck1710 FIND v(dout1_19) AT=1720.05n

.meas tran vdout1_0ck1770 FIND v(dout1_0) AT=1780.05n

.meas tran vdout1_1ck1770 FIND v(dout1_1) AT=1780.05n

.meas tran vdout1_2ck1770 FIND v(dout1_2) AT=1780.05n

.meas tran vdout1_3ck1770 FIND v(dout1_3) AT=1780.05n

.meas tran vdout1_4ck1770 FIND v(dout1_4) AT=1780.05n

.meas tran vdout1_5ck1770 FIND v(dout1_5) AT=1780.05n

.meas tran vdout1_6ck1770 FIND v(dout1_6) AT=1780.05n

.meas tran vdout1_7ck1770 FIND v(dout1_7) AT=1780.05n

.meas tran vdout1_8ck1770 FIND v(dout1_8) AT=1780.05n

.meas tran vdout1_9ck1770 FIND v(dout1_9) AT=1780.05n

.meas tran vdout1_10ck1770 FIND v(dout1_10) AT=1780.05n

.meas tran vdout1_11ck1770 FIND v(dout1_11) AT=1780.05n

.meas tran vdout1_12ck1770 FIND v(dout1_12) AT=1780.05n

.meas tran vdout1_13ck1770 FIND v(dout1_13) AT=1780.05n

.meas tran vdout1_14ck1770 FIND v(dout1_14) AT=1780.05n

.meas tran vdout1_15ck1770 FIND v(dout1_15) AT=1780.05n

.meas tran vdout1_16ck1770 FIND v(dout1_16) AT=1780.05n

.meas tran vdout1_17ck1770 FIND v(dout1_17) AT=1780.05n

.meas tran vdout1_18ck1770 FIND v(dout1_18) AT=1780.05n

.meas tran vdout1_19ck1770 FIND v(dout1_19) AT=1780.05n

.meas tran vdout1_0ck1800 FIND v(dout1_0) AT=1810.05n

.meas tran vdout1_1ck1800 FIND v(dout1_1) AT=1810.05n

.meas tran vdout1_2ck1800 FIND v(dout1_2) AT=1810.05n

.meas tran vdout1_3ck1800 FIND v(dout1_3) AT=1810.05n

.meas tran vdout1_4ck1800 FIND v(dout1_4) AT=1810.05n

.meas tran vdout1_5ck1800 FIND v(dout1_5) AT=1810.05n

.meas tran vdout1_6ck1800 FIND v(dout1_6) AT=1810.05n

.meas tran vdout1_7ck1800 FIND v(dout1_7) AT=1810.05n

.meas tran vdout1_8ck1800 FIND v(dout1_8) AT=1810.05n

.meas tran vdout1_9ck1800 FIND v(dout1_9) AT=1810.05n

.meas tran vdout1_10ck1800 FIND v(dout1_10) AT=1810.05n

.meas tran vdout1_11ck1800 FIND v(dout1_11) AT=1810.05n

.meas tran vdout1_12ck1800 FIND v(dout1_12) AT=1810.05n

.meas tran vdout1_13ck1800 FIND v(dout1_13) AT=1810.05n

.meas tran vdout1_14ck1800 FIND v(dout1_14) AT=1810.05n

.meas tran vdout1_15ck1800 FIND v(dout1_15) AT=1810.05n

.meas tran vdout1_16ck1800 FIND v(dout1_16) AT=1810.05n

.meas tran vdout1_17ck1800 FIND v(dout1_17) AT=1810.05n

.meas tran vdout1_18ck1800 FIND v(dout1_18) AT=1810.05n

.meas tran vdout1_19ck1800 FIND v(dout1_19) AT=1810.05n

.meas tran vdout1_0ck1830 FIND v(dout1_0) AT=1840.05n

.meas tran vdout1_1ck1830 FIND v(dout1_1) AT=1840.05n

.meas tran vdout1_2ck1830 FIND v(dout1_2) AT=1840.05n

.meas tran vdout1_3ck1830 FIND v(dout1_3) AT=1840.05n

.meas tran vdout1_4ck1830 FIND v(dout1_4) AT=1840.05n

.meas tran vdout1_5ck1830 FIND v(dout1_5) AT=1840.05n

.meas tran vdout1_6ck1830 FIND v(dout1_6) AT=1840.05n

.meas tran vdout1_7ck1830 FIND v(dout1_7) AT=1840.05n

.meas tran vdout1_8ck1830 FIND v(dout1_8) AT=1840.05n

.meas tran vdout1_9ck1830 FIND v(dout1_9) AT=1840.05n

.meas tran vdout1_10ck1830 FIND v(dout1_10) AT=1840.05n

.meas tran vdout1_11ck1830 FIND v(dout1_11) AT=1840.05n

.meas tran vdout1_12ck1830 FIND v(dout1_12) AT=1840.05n

.meas tran vdout1_13ck1830 FIND v(dout1_13) AT=1840.05n

.meas tran vdout1_14ck1830 FIND v(dout1_14) AT=1840.05n

.meas tran vdout1_15ck1830 FIND v(dout1_15) AT=1840.05n

.meas tran vdout1_16ck1830 FIND v(dout1_16) AT=1840.05n

.meas tran vdout1_17ck1830 FIND v(dout1_17) AT=1840.05n

.meas tran vdout1_18ck1830 FIND v(dout1_18) AT=1840.05n

.meas tran vdout1_19ck1830 FIND v(dout1_19) AT=1840.05n

.meas tran vdout1_0ck1840 FIND v(dout1_0) AT=1850.05n

.meas tran vdout1_1ck1840 FIND v(dout1_1) AT=1850.05n

.meas tran vdout1_2ck1840 FIND v(dout1_2) AT=1850.05n

.meas tran vdout1_3ck1840 FIND v(dout1_3) AT=1850.05n

.meas tran vdout1_4ck1840 FIND v(dout1_4) AT=1850.05n

.meas tran vdout1_5ck1840 FIND v(dout1_5) AT=1850.05n

.meas tran vdout1_6ck1840 FIND v(dout1_6) AT=1850.05n

.meas tran vdout1_7ck1840 FIND v(dout1_7) AT=1850.05n

.meas tran vdout1_8ck1840 FIND v(dout1_8) AT=1850.05n

.meas tran vdout1_9ck1840 FIND v(dout1_9) AT=1850.05n

.meas tran vdout1_10ck1840 FIND v(dout1_10) AT=1850.05n

.meas tran vdout1_11ck1840 FIND v(dout1_11) AT=1850.05n

.meas tran vdout1_12ck1840 FIND v(dout1_12) AT=1850.05n

.meas tran vdout1_13ck1840 FIND v(dout1_13) AT=1850.05n

.meas tran vdout1_14ck1840 FIND v(dout1_14) AT=1850.05n

.meas tran vdout1_15ck1840 FIND v(dout1_15) AT=1850.05n

.meas tran vdout1_16ck1840 FIND v(dout1_16) AT=1850.05n

.meas tran vdout1_17ck1840 FIND v(dout1_17) AT=1850.05n

.meas tran vdout1_18ck1840 FIND v(dout1_18) AT=1850.05n

.meas tran vdout1_19ck1840 FIND v(dout1_19) AT=1850.05n

.meas tran vdout1_0ck1870 FIND v(dout1_0) AT=1880.05n

.meas tran vdout1_1ck1870 FIND v(dout1_1) AT=1880.05n

.meas tran vdout1_2ck1870 FIND v(dout1_2) AT=1880.05n

.meas tran vdout1_3ck1870 FIND v(dout1_3) AT=1880.05n

.meas tran vdout1_4ck1870 FIND v(dout1_4) AT=1880.05n

.meas tran vdout1_5ck1870 FIND v(dout1_5) AT=1880.05n

.meas tran vdout1_6ck1870 FIND v(dout1_6) AT=1880.05n

.meas tran vdout1_7ck1870 FIND v(dout1_7) AT=1880.05n

.meas tran vdout1_8ck1870 FIND v(dout1_8) AT=1880.05n

.meas tran vdout1_9ck1870 FIND v(dout1_9) AT=1880.05n

.meas tran vdout1_10ck1870 FIND v(dout1_10) AT=1880.05n

.meas tran vdout1_11ck1870 FIND v(dout1_11) AT=1880.05n

.meas tran vdout1_12ck1870 FIND v(dout1_12) AT=1880.05n

.meas tran vdout1_13ck1870 FIND v(dout1_13) AT=1880.05n

.meas tran vdout1_14ck1870 FIND v(dout1_14) AT=1880.05n

.meas tran vdout1_15ck1870 FIND v(dout1_15) AT=1880.05n

.meas tran vdout1_16ck1870 FIND v(dout1_16) AT=1880.05n

.meas tran vdout1_17ck1870 FIND v(dout1_17) AT=1880.05n

.meas tran vdout1_18ck1870 FIND v(dout1_18) AT=1880.05n

.meas tran vdout1_19ck1870 FIND v(dout1_19) AT=1880.05n

.meas tran vdout1_0ck1880 FIND v(dout1_0) AT=1890.05n

.meas tran vdout1_1ck1880 FIND v(dout1_1) AT=1890.05n

.meas tran vdout1_2ck1880 FIND v(dout1_2) AT=1890.05n

.meas tran vdout1_3ck1880 FIND v(dout1_3) AT=1890.05n

.meas tran vdout1_4ck1880 FIND v(dout1_4) AT=1890.05n

.meas tran vdout1_5ck1880 FIND v(dout1_5) AT=1890.05n

.meas tran vdout1_6ck1880 FIND v(dout1_6) AT=1890.05n

.meas tran vdout1_7ck1880 FIND v(dout1_7) AT=1890.05n

.meas tran vdout1_8ck1880 FIND v(dout1_8) AT=1890.05n

.meas tran vdout1_9ck1880 FIND v(dout1_9) AT=1890.05n

.meas tran vdout1_10ck1880 FIND v(dout1_10) AT=1890.05n

.meas tran vdout1_11ck1880 FIND v(dout1_11) AT=1890.05n

.meas tran vdout1_12ck1880 FIND v(dout1_12) AT=1890.05n

.meas tran vdout1_13ck1880 FIND v(dout1_13) AT=1890.05n

.meas tran vdout1_14ck1880 FIND v(dout1_14) AT=1890.05n

.meas tran vdout1_15ck1880 FIND v(dout1_15) AT=1890.05n

.meas tran vdout1_16ck1880 FIND v(dout1_16) AT=1890.05n

.meas tran vdout1_17ck1880 FIND v(dout1_17) AT=1890.05n

.meas tran vdout1_18ck1880 FIND v(dout1_18) AT=1890.05n

.meas tran vdout1_19ck1880 FIND v(dout1_19) AT=1890.05n

.meas tran vdout1_0ck1890 FIND v(dout1_0) AT=1900.05n

.meas tran vdout1_1ck1890 FIND v(dout1_1) AT=1900.05n

.meas tran vdout1_2ck1890 FIND v(dout1_2) AT=1900.05n

.meas tran vdout1_3ck1890 FIND v(dout1_3) AT=1900.05n

.meas tran vdout1_4ck1890 FIND v(dout1_4) AT=1900.05n

.meas tran vdout1_5ck1890 FIND v(dout1_5) AT=1900.05n

.meas tran vdout1_6ck1890 FIND v(dout1_6) AT=1900.05n

.meas tran vdout1_7ck1890 FIND v(dout1_7) AT=1900.05n

.meas tran vdout1_8ck1890 FIND v(dout1_8) AT=1900.05n

.meas tran vdout1_9ck1890 FIND v(dout1_9) AT=1900.05n

.meas tran vdout1_10ck1890 FIND v(dout1_10) AT=1900.05n

.meas tran vdout1_11ck1890 FIND v(dout1_11) AT=1900.05n

.meas tran vdout1_12ck1890 FIND v(dout1_12) AT=1900.05n

.meas tran vdout1_13ck1890 FIND v(dout1_13) AT=1900.05n

.meas tran vdout1_14ck1890 FIND v(dout1_14) AT=1900.05n

.meas tran vdout1_15ck1890 FIND v(dout1_15) AT=1900.05n

.meas tran vdout1_16ck1890 FIND v(dout1_16) AT=1900.05n

.meas tran vdout1_17ck1890 FIND v(dout1_17) AT=1900.05n

.meas tran vdout1_18ck1890 FIND v(dout1_18) AT=1900.05n

.meas tran vdout1_19ck1890 FIND v(dout1_19) AT=1900.05n

.meas tran vdout1_0ck1910 FIND v(dout1_0) AT=1920.05n

.meas tran vdout1_1ck1910 FIND v(dout1_1) AT=1920.05n

.meas tran vdout1_2ck1910 FIND v(dout1_2) AT=1920.05n

.meas tran vdout1_3ck1910 FIND v(dout1_3) AT=1920.05n

.meas tran vdout1_4ck1910 FIND v(dout1_4) AT=1920.05n

.meas tran vdout1_5ck1910 FIND v(dout1_5) AT=1920.05n

.meas tran vdout1_6ck1910 FIND v(dout1_6) AT=1920.05n

.meas tran vdout1_7ck1910 FIND v(dout1_7) AT=1920.05n

.meas tran vdout1_8ck1910 FIND v(dout1_8) AT=1920.05n

.meas tran vdout1_9ck1910 FIND v(dout1_9) AT=1920.05n

.meas tran vdout1_10ck1910 FIND v(dout1_10) AT=1920.05n

.meas tran vdout1_11ck1910 FIND v(dout1_11) AT=1920.05n

.meas tran vdout1_12ck1910 FIND v(dout1_12) AT=1920.05n

.meas tran vdout1_13ck1910 FIND v(dout1_13) AT=1920.05n

.meas tran vdout1_14ck1910 FIND v(dout1_14) AT=1920.05n

.meas tran vdout1_15ck1910 FIND v(dout1_15) AT=1920.05n

.meas tran vdout1_16ck1910 FIND v(dout1_16) AT=1920.05n

.meas tran vdout1_17ck1910 FIND v(dout1_17) AT=1920.05n

.meas tran vdout1_18ck1910 FIND v(dout1_18) AT=1920.05n

.meas tran vdout1_19ck1910 FIND v(dout1_19) AT=1920.05n

.meas tran vdout1_0ck1920 FIND v(dout1_0) AT=1930.05n

.meas tran vdout1_1ck1920 FIND v(dout1_1) AT=1930.05n

.meas tran vdout1_2ck1920 FIND v(dout1_2) AT=1930.05n

.meas tran vdout1_3ck1920 FIND v(dout1_3) AT=1930.05n

.meas tran vdout1_4ck1920 FIND v(dout1_4) AT=1930.05n

.meas tran vdout1_5ck1920 FIND v(dout1_5) AT=1930.05n

.meas tran vdout1_6ck1920 FIND v(dout1_6) AT=1930.05n

.meas tran vdout1_7ck1920 FIND v(dout1_7) AT=1930.05n

.meas tran vdout1_8ck1920 FIND v(dout1_8) AT=1930.05n

.meas tran vdout1_9ck1920 FIND v(dout1_9) AT=1930.05n

.meas tran vdout1_10ck1920 FIND v(dout1_10) AT=1930.05n

.meas tran vdout1_11ck1920 FIND v(dout1_11) AT=1930.05n

.meas tran vdout1_12ck1920 FIND v(dout1_12) AT=1930.05n

.meas tran vdout1_13ck1920 FIND v(dout1_13) AT=1930.05n

.meas tran vdout1_14ck1920 FIND v(dout1_14) AT=1930.05n

.meas tran vdout1_15ck1920 FIND v(dout1_15) AT=1930.05n

.meas tran vdout1_16ck1920 FIND v(dout1_16) AT=1930.05n

.meas tran vdout1_17ck1920 FIND v(dout1_17) AT=1930.05n

.meas tran vdout1_18ck1920 FIND v(dout1_18) AT=1930.05n

.meas tran vdout1_19ck1920 FIND v(dout1_19) AT=1930.05n

.meas tran vdout1_0ck1930 FIND v(dout1_0) AT=1940.05n

.meas tran vdout1_1ck1930 FIND v(dout1_1) AT=1940.05n

.meas tran vdout1_2ck1930 FIND v(dout1_2) AT=1940.05n

.meas tran vdout1_3ck1930 FIND v(dout1_3) AT=1940.05n

.meas tran vdout1_4ck1930 FIND v(dout1_4) AT=1940.05n

.meas tran vdout1_5ck1930 FIND v(dout1_5) AT=1940.05n

.meas tran vdout1_6ck1930 FIND v(dout1_6) AT=1940.05n

.meas tran vdout1_7ck1930 FIND v(dout1_7) AT=1940.05n

.meas tran vdout1_8ck1930 FIND v(dout1_8) AT=1940.05n

.meas tran vdout1_9ck1930 FIND v(dout1_9) AT=1940.05n

.meas tran vdout1_10ck1930 FIND v(dout1_10) AT=1940.05n

.meas tran vdout1_11ck1930 FIND v(dout1_11) AT=1940.05n

.meas tran vdout1_12ck1930 FIND v(dout1_12) AT=1940.05n

.meas tran vdout1_13ck1930 FIND v(dout1_13) AT=1940.05n

.meas tran vdout1_14ck1930 FIND v(dout1_14) AT=1940.05n

.meas tran vdout1_15ck1930 FIND v(dout1_15) AT=1940.05n

.meas tran vdout1_16ck1930 FIND v(dout1_16) AT=1940.05n

.meas tran vdout1_17ck1930 FIND v(dout1_17) AT=1940.05n

.meas tran vdout1_18ck1930 FIND v(dout1_18) AT=1940.05n

.meas tran vdout1_19ck1930 FIND v(dout1_19) AT=1940.05n

.meas tran vdout1_0ck1940 FIND v(dout1_0) AT=1950.05n

.meas tran vdout1_1ck1940 FIND v(dout1_1) AT=1950.05n

.meas tran vdout1_2ck1940 FIND v(dout1_2) AT=1950.05n

.meas tran vdout1_3ck1940 FIND v(dout1_3) AT=1950.05n

.meas tran vdout1_4ck1940 FIND v(dout1_4) AT=1950.05n

.meas tran vdout1_5ck1940 FIND v(dout1_5) AT=1950.05n

.meas tran vdout1_6ck1940 FIND v(dout1_6) AT=1950.05n

.meas tran vdout1_7ck1940 FIND v(dout1_7) AT=1950.05n

.meas tran vdout1_8ck1940 FIND v(dout1_8) AT=1950.05n

.meas tran vdout1_9ck1940 FIND v(dout1_9) AT=1950.05n

.meas tran vdout1_10ck1940 FIND v(dout1_10) AT=1950.05n

.meas tran vdout1_11ck1940 FIND v(dout1_11) AT=1950.05n

.meas tran vdout1_12ck1940 FIND v(dout1_12) AT=1950.05n

.meas tran vdout1_13ck1940 FIND v(dout1_13) AT=1950.05n

.meas tran vdout1_14ck1940 FIND v(dout1_14) AT=1950.05n

.meas tran vdout1_15ck1940 FIND v(dout1_15) AT=1950.05n

.meas tran vdout1_16ck1940 FIND v(dout1_16) AT=1950.05n

.meas tran vdout1_17ck1940 FIND v(dout1_17) AT=1950.05n

.meas tran vdout1_18ck1940 FIND v(dout1_18) AT=1950.05n

.meas tran vdout1_19ck1940 FIND v(dout1_19) AT=1950.05n

.meas tran vdout1_0ck1950 FIND v(dout1_0) AT=1960.05n

.meas tran vdout1_1ck1950 FIND v(dout1_1) AT=1960.05n

.meas tran vdout1_2ck1950 FIND v(dout1_2) AT=1960.05n

.meas tran vdout1_3ck1950 FIND v(dout1_3) AT=1960.05n

.meas tran vdout1_4ck1950 FIND v(dout1_4) AT=1960.05n

.meas tran vdout1_5ck1950 FIND v(dout1_5) AT=1960.05n

.meas tran vdout1_6ck1950 FIND v(dout1_6) AT=1960.05n

.meas tran vdout1_7ck1950 FIND v(dout1_7) AT=1960.05n

.meas tran vdout1_8ck1950 FIND v(dout1_8) AT=1960.05n

.meas tran vdout1_9ck1950 FIND v(dout1_9) AT=1960.05n

.meas tran vdout1_10ck1950 FIND v(dout1_10) AT=1960.05n

.meas tran vdout1_11ck1950 FIND v(dout1_11) AT=1960.05n

.meas tran vdout1_12ck1950 FIND v(dout1_12) AT=1960.05n

.meas tran vdout1_13ck1950 FIND v(dout1_13) AT=1960.05n

.meas tran vdout1_14ck1950 FIND v(dout1_14) AT=1960.05n

.meas tran vdout1_15ck1950 FIND v(dout1_15) AT=1960.05n

.meas tran vdout1_16ck1950 FIND v(dout1_16) AT=1960.05n

.meas tran vdout1_17ck1950 FIND v(dout1_17) AT=1960.05n

.meas tran vdout1_18ck1950 FIND v(dout1_18) AT=1960.05n

.meas tran vdout1_19ck1950 FIND v(dout1_19) AT=1960.05n

.meas tran vdout1_0ck2000 FIND v(dout1_0) AT=2010.05n

.meas tran vdout1_1ck2000 FIND v(dout1_1) AT=2010.05n

.meas tran vdout1_2ck2000 FIND v(dout1_2) AT=2010.05n

.meas tran vdout1_3ck2000 FIND v(dout1_3) AT=2010.05n

.meas tran vdout1_4ck2000 FIND v(dout1_4) AT=2010.05n

.meas tran vdout1_5ck2000 FIND v(dout1_5) AT=2010.05n

.meas tran vdout1_6ck2000 FIND v(dout1_6) AT=2010.05n

.meas tran vdout1_7ck2000 FIND v(dout1_7) AT=2010.05n

.meas tran vdout1_8ck2000 FIND v(dout1_8) AT=2010.05n

.meas tran vdout1_9ck2000 FIND v(dout1_9) AT=2010.05n

.meas tran vdout1_10ck2000 FIND v(dout1_10) AT=2010.05n

.meas tran vdout1_11ck2000 FIND v(dout1_11) AT=2010.05n

.meas tran vdout1_12ck2000 FIND v(dout1_12) AT=2010.05n

.meas tran vdout1_13ck2000 FIND v(dout1_13) AT=2010.05n

.meas tran vdout1_14ck2000 FIND v(dout1_14) AT=2010.05n

.meas tran vdout1_15ck2000 FIND v(dout1_15) AT=2010.05n

.meas tran vdout1_16ck2000 FIND v(dout1_16) AT=2010.05n

.meas tran vdout1_17ck2000 FIND v(dout1_17) AT=2010.05n

.meas tran vdout1_18ck2000 FIND v(dout1_18) AT=2010.05n

.meas tran vdout1_19ck2000 FIND v(dout1_19) AT=2010.05n

.meas tran vdout1_0ck2020 FIND v(dout1_0) AT=2030.05n

.meas tran vdout1_1ck2020 FIND v(dout1_1) AT=2030.05n

.meas tran vdout1_2ck2020 FIND v(dout1_2) AT=2030.05n

.meas tran vdout1_3ck2020 FIND v(dout1_3) AT=2030.05n

.meas tran vdout1_4ck2020 FIND v(dout1_4) AT=2030.05n

.meas tran vdout1_5ck2020 FIND v(dout1_5) AT=2030.05n

.meas tran vdout1_6ck2020 FIND v(dout1_6) AT=2030.05n

.meas tran vdout1_7ck2020 FIND v(dout1_7) AT=2030.05n

.meas tran vdout1_8ck2020 FIND v(dout1_8) AT=2030.05n

.meas tran vdout1_9ck2020 FIND v(dout1_9) AT=2030.05n

.meas tran vdout1_10ck2020 FIND v(dout1_10) AT=2030.05n

.meas tran vdout1_11ck2020 FIND v(dout1_11) AT=2030.05n

.meas tran vdout1_12ck2020 FIND v(dout1_12) AT=2030.05n

.meas tran vdout1_13ck2020 FIND v(dout1_13) AT=2030.05n

.meas tran vdout1_14ck2020 FIND v(dout1_14) AT=2030.05n

.meas tran vdout1_15ck2020 FIND v(dout1_15) AT=2030.05n

.meas tran vdout1_16ck2020 FIND v(dout1_16) AT=2030.05n

.meas tran vdout1_17ck2020 FIND v(dout1_17) AT=2030.05n

.meas tran vdout1_18ck2020 FIND v(dout1_18) AT=2030.05n

.meas tran vdout1_19ck2020 FIND v(dout1_19) AT=2030.05n

.meas tran vdout1_0ck2030 FIND v(dout1_0) AT=2040.05n

.meas tran vdout1_1ck2030 FIND v(dout1_1) AT=2040.05n

.meas tran vdout1_2ck2030 FIND v(dout1_2) AT=2040.05n

.meas tran vdout1_3ck2030 FIND v(dout1_3) AT=2040.05n

.meas tran vdout1_4ck2030 FIND v(dout1_4) AT=2040.05n

.meas tran vdout1_5ck2030 FIND v(dout1_5) AT=2040.05n

.meas tran vdout1_6ck2030 FIND v(dout1_6) AT=2040.05n

.meas tran vdout1_7ck2030 FIND v(dout1_7) AT=2040.05n

.meas tran vdout1_8ck2030 FIND v(dout1_8) AT=2040.05n

.meas tran vdout1_9ck2030 FIND v(dout1_9) AT=2040.05n

.meas tran vdout1_10ck2030 FIND v(dout1_10) AT=2040.05n

.meas tran vdout1_11ck2030 FIND v(dout1_11) AT=2040.05n

.meas tran vdout1_12ck2030 FIND v(dout1_12) AT=2040.05n

.meas tran vdout1_13ck2030 FIND v(dout1_13) AT=2040.05n

.meas tran vdout1_14ck2030 FIND v(dout1_14) AT=2040.05n

.meas tran vdout1_15ck2030 FIND v(dout1_15) AT=2040.05n

.meas tran vdout1_16ck2030 FIND v(dout1_16) AT=2040.05n

.meas tran vdout1_17ck2030 FIND v(dout1_17) AT=2040.05n

.meas tran vdout1_18ck2030 FIND v(dout1_18) AT=2040.05n

.meas tran vdout1_19ck2030 FIND v(dout1_19) AT=2040.05n

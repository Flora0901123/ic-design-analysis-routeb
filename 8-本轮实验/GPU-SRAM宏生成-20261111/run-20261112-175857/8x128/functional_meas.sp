.meas tran vdout1_0ck40 FIND v(dout1_0) AT=50.05n

.meas tran vdout1_1ck40 FIND v(dout1_1) AT=50.05n

.meas tran vdout1_2ck40 FIND v(dout1_2) AT=50.05n

.meas tran vdout1_3ck40 FIND v(dout1_3) AT=50.05n

.meas tran vdout1_4ck40 FIND v(dout1_4) AT=50.05n

.meas tran vdout1_5ck40 FIND v(dout1_5) AT=50.05n

.meas tran vdout1_6ck40 FIND v(dout1_6) AT=50.05n

.meas tran vdout1_7ck40 FIND v(dout1_7) AT=50.05n

.meas tran vdout1_0ck60 FIND v(dout1_0) AT=70.05n

.meas tran vdout1_1ck60 FIND v(dout1_1) AT=70.05n

.meas tran vdout1_2ck60 FIND v(dout1_2) AT=70.05n

.meas tran vdout1_3ck60 FIND v(dout1_3) AT=70.05n

.meas tran vdout1_4ck60 FIND v(dout1_4) AT=70.05n

.meas tran vdout1_5ck60 FIND v(dout1_5) AT=70.05n

.meas tran vdout1_6ck60 FIND v(dout1_6) AT=70.05n

.meas tran vdout1_7ck60 FIND v(dout1_7) AT=70.05n

.meas tran vdout1_0ck100 FIND v(dout1_0) AT=110.05n

.meas tran vdout1_1ck100 FIND v(dout1_1) AT=110.05n

.meas tran vdout1_2ck100 FIND v(dout1_2) AT=110.05n

.meas tran vdout1_3ck100 FIND v(dout1_3) AT=110.05n

.meas tran vdout1_4ck100 FIND v(dout1_4) AT=110.05n

.meas tran vdout1_5ck100 FIND v(dout1_5) AT=110.05n

.meas tran vdout1_6ck100 FIND v(dout1_6) AT=110.05n

.meas tran vdout1_7ck100 FIND v(dout1_7) AT=110.05n

.meas tran vdout1_0ck120 FIND v(dout1_0) AT=130.05n

.meas tran vdout1_1ck120 FIND v(dout1_1) AT=130.05n

.meas tran vdout1_2ck120 FIND v(dout1_2) AT=130.05n

.meas tran vdout1_3ck120 FIND v(dout1_3) AT=130.05n

.meas tran vdout1_4ck120 FIND v(dout1_4) AT=130.05n

.meas tran vdout1_5ck120 FIND v(dout1_5) AT=130.05n

.meas tran vdout1_6ck120 FIND v(dout1_6) AT=130.05n

.meas tran vdout1_7ck120 FIND v(dout1_7) AT=130.05n

.meas tran vdout1_0ck140 FIND v(dout1_0) AT=150.05n

.meas tran vdout1_1ck140 FIND v(dout1_1) AT=150.05n

.meas tran vdout1_2ck140 FIND v(dout1_2) AT=150.05n

.meas tran vdout1_3ck140 FIND v(dout1_3) AT=150.05n

.meas tran vdout1_4ck140 FIND v(dout1_4) AT=150.05n

.meas tran vdout1_5ck140 FIND v(dout1_5) AT=150.05n

.meas tran vdout1_6ck140 FIND v(dout1_6) AT=150.05n

.meas tran vdout1_7ck140 FIND v(dout1_7) AT=150.05n

.meas tran vdout1_0ck160 FIND v(dout1_0) AT=170.05n

.meas tran vdout1_1ck160 FIND v(dout1_1) AT=170.05n

.meas tran vdout1_2ck160 FIND v(dout1_2) AT=170.05n

.meas tran vdout1_3ck160 FIND v(dout1_3) AT=170.05n

.meas tran vdout1_4ck160 FIND v(dout1_4) AT=170.05n

.meas tran vdout1_5ck160 FIND v(dout1_5) AT=170.05n

.meas tran vdout1_6ck160 FIND v(dout1_6) AT=170.05n

.meas tran vdout1_7ck160 FIND v(dout1_7) AT=170.05n

.meas tran vdout1_0ck180 FIND v(dout1_0) AT=190.05n

.meas tran vdout1_1ck180 FIND v(dout1_1) AT=190.05n

.meas tran vdout1_2ck180 FIND v(dout1_2) AT=190.05n

.meas tran vdout1_3ck180 FIND v(dout1_3) AT=190.05n

.meas tran vdout1_4ck180 FIND v(dout1_4) AT=190.05n

.meas tran vdout1_5ck180 FIND v(dout1_5) AT=190.05n

.meas tran vdout1_6ck180 FIND v(dout1_6) AT=190.05n

.meas tran vdout1_7ck180 FIND v(dout1_7) AT=190.05n

.meas tran vdout1_0ck190 FIND v(dout1_0) AT=200.05n

.meas tran vdout1_1ck190 FIND v(dout1_1) AT=200.05n

.meas tran vdout1_2ck190 FIND v(dout1_2) AT=200.05n

.meas tran vdout1_3ck190 FIND v(dout1_3) AT=200.05n

.meas tran vdout1_4ck190 FIND v(dout1_4) AT=200.05n

.meas tran vdout1_5ck190 FIND v(dout1_5) AT=200.05n

.meas tran vdout1_6ck190 FIND v(dout1_6) AT=200.05n

.meas tran vdout1_7ck190 FIND v(dout1_7) AT=200.05n

.meas tran vdout1_0ck210 FIND v(dout1_0) AT=220.05n

.meas tran vdout1_1ck210 FIND v(dout1_1) AT=220.05n

.meas tran vdout1_2ck210 FIND v(dout1_2) AT=220.05n

.meas tran vdout1_3ck210 FIND v(dout1_3) AT=220.05n

.meas tran vdout1_4ck210 FIND v(dout1_4) AT=220.05n

.meas tran vdout1_5ck210 FIND v(dout1_5) AT=220.05n

.meas tran vdout1_6ck210 FIND v(dout1_6) AT=220.05n

.meas tran vdout1_7ck210 FIND v(dout1_7) AT=220.05n

.meas tran vdout1_0ck260 FIND v(dout1_0) AT=270.05n

.meas tran vdout1_1ck260 FIND v(dout1_1) AT=270.05n

.meas tran vdout1_2ck260 FIND v(dout1_2) AT=270.05n

.meas tran vdout1_3ck260 FIND v(dout1_3) AT=270.05n

.meas tran vdout1_4ck260 FIND v(dout1_4) AT=270.05n

.meas tran vdout1_5ck260 FIND v(dout1_5) AT=270.05n

.meas tran vdout1_6ck260 FIND v(dout1_6) AT=270.05n

.meas tran vdout1_7ck260 FIND v(dout1_7) AT=270.05n

.meas tran vdout1_0ck270 FIND v(dout1_0) AT=280.05n

.meas tran vdout1_1ck270 FIND v(dout1_1) AT=280.05n

.meas tran vdout1_2ck270 FIND v(dout1_2) AT=280.05n

.meas tran vdout1_3ck270 FIND v(dout1_3) AT=280.05n

.meas tran vdout1_4ck270 FIND v(dout1_4) AT=280.05n

.meas tran vdout1_5ck270 FIND v(dout1_5) AT=280.05n

.meas tran vdout1_6ck270 FIND v(dout1_6) AT=280.05n

.meas tran vdout1_7ck270 FIND v(dout1_7) AT=280.05n

.meas tran vdout1_0ck300 FIND v(dout1_0) AT=310.05n

.meas tran vdout1_1ck300 FIND v(dout1_1) AT=310.05n

.meas tran vdout1_2ck300 FIND v(dout1_2) AT=310.05n

.meas tran vdout1_3ck300 FIND v(dout1_3) AT=310.05n

.meas tran vdout1_4ck300 FIND v(dout1_4) AT=310.05n

.meas tran vdout1_5ck300 FIND v(dout1_5) AT=310.05n

.meas tran vdout1_6ck300 FIND v(dout1_6) AT=310.05n

.meas tran vdout1_7ck300 FIND v(dout1_7) AT=310.05n

.meas tran vdout1_0ck310 FIND v(dout1_0) AT=320.05n

.meas tran vdout1_1ck310 FIND v(dout1_1) AT=320.05n

.meas tran vdout1_2ck310 FIND v(dout1_2) AT=320.05n

.meas tran vdout1_3ck310 FIND v(dout1_3) AT=320.05n

.meas tran vdout1_4ck310 FIND v(dout1_4) AT=320.05n

.meas tran vdout1_5ck310 FIND v(dout1_5) AT=320.05n

.meas tran vdout1_6ck310 FIND v(dout1_6) AT=320.05n

.meas tran vdout1_7ck310 FIND v(dout1_7) AT=320.05n

.meas tran vdout1_0ck320 FIND v(dout1_0) AT=330.05n

.meas tran vdout1_1ck320 FIND v(dout1_1) AT=330.05n

.meas tran vdout1_2ck320 FIND v(dout1_2) AT=330.05n

.meas tran vdout1_3ck320 FIND v(dout1_3) AT=330.05n

.meas tran vdout1_4ck320 FIND v(dout1_4) AT=330.05n

.meas tran vdout1_5ck320 FIND v(dout1_5) AT=330.05n

.meas tran vdout1_6ck320 FIND v(dout1_6) AT=330.05n

.meas tran vdout1_7ck320 FIND v(dout1_7) AT=330.05n

.meas tran vdout1_0ck400 FIND v(dout1_0) AT=410.05n

.meas tran vdout1_1ck400 FIND v(dout1_1) AT=410.05n

.meas tran vdout1_2ck400 FIND v(dout1_2) AT=410.05n

.meas tran vdout1_3ck400 FIND v(dout1_3) AT=410.05n

.meas tran vdout1_4ck400 FIND v(dout1_4) AT=410.05n

.meas tran vdout1_5ck400 FIND v(dout1_5) AT=410.05n

.meas tran vdout1_6ck400 FIND v(dout1_6) AT=410.05n

.meas tran vdout1_7ck400 FIND v(dout1_7) AT=410.05n

.meas tran vdout1_0ck460 FIND v(dout1_0) AT=470.05n

.meas tran vdout1_1ck460 FIND v(dout1_1) AT=470.05n

.meas tran vdout1_2ck460 FIND v(dout1_2) AT=470.05n

.meas tran vdout1_3ck460 FIND v(dout1_3) AT=470.05n

.meas tran vdout1_4ck460 FIND v(dout1_4) AT=470.05n

.meas tran vdout1_5ck460 FIND v(dout1_5) AT=470.05n

.meas tran vdout1_6ck460 FIND v(dout1_6) AT=470.05n

.meas tran vdout1_7ck460 FIND v(dout1_7) AT=470.05n

.meas tran vdout1_0ck470 FIND v(dout1_0) AT=480.05n

.meas tran vdout1_1ck470 FIND v(dout1_1) AT=480.05n

.meas tran vdout1_2ck470 FIND v(dout1_2) AT=480.05n

.meas tran vdout1_3ck470 FIND v(dout1_3) AT=480.05n

.meas tran vdout1_4ck470 FIND v(dout1_4) AT=480.05n

.meas tran vdout1_5ck470 FIND v(dout1_5) AT=480.05n

.meas tran vdout1_6ck470 FIND v(dout1_6) AT=480.05n

.meas tran vdout1_7ck470 FIND v(dout1_7) AT=480.05n

.meas tran vdout1_0ck520 FIND v(dout1_0) AT=530.05n

.meas tran vdout1_1ck520 FIND v(dout1_1) AT=530.05n

.meas tran vdout1_2ck520 FIND v(dout1_2) AT=530.05n

.meas tran vdout1_3ck520 FIND v(dout1_3) AT=530.05n

.meas tran vdout1_4ck520 FIND v(dout1_4) AT=530.05n

.meas tran vdout1_5ck520 FIND v(dout1_5) AT=530.05n

.meas tran vdout1_6ck520 FIND v(dout1_6) AT=530.05n

.meas tran vdout1_7ck520 FIND v(dout1_7) AT=530.05n

.meas tran vdout1_0ck540 FIND v(dout1_0) AT=550.05n

.meas tran vdout1_1ck540 FIND v(dout1_1) AT=550.05n

.meas tran vdout1_2ck540 FIND v(dout1_2) AT=550.05n

.meas tran vdout1_3ck540 FIND v(dout1_3) AT=550.05n

.meas tran vdout1_4ck540 FIND v(dout1_4) AT=550.05n

.meas tran vdout1_5ck540 FIND v(dout1_5) AT=550.05n

.meas tran vdout1_6ck540 FIND v(dout1_6) AT=550.05n

.meas tran vdout1_7ck540 FIND v(dout1_7) AT=550.05n

.meas tran vdout1_0ck550 FIND v(dout1_0) AT=560.05n

.meas tran vdout1_1ck550 FIND v(dout1_1) AT=560.05n

.meas tran vdout1_2ck550 FIND v(dout1_2) AT=560.05n

.meas tran vdout1_3ck550 FIND v(dout1_3) AT=560.05n

.meas tran vdout1_4ck550 FIND v(dout1_4) AT=560.05n

.meas tran vdout1_5ck550 FIND v(dout1_5) AT=560.05n

.meas tran vdout1_6ck550 FIND v(dout1_6) AT=560.05n

.meas tran vdout1_7ck550 FIND v(dout1_7) AT=560.05n

.meas tran vdout1_0ck560 FIND v(dout1_0) AT=570.05n

.meas tran vdout1_1ck560 FIND v(dout1_1) AT=570.05n

.meas tran vdout1_2ck560 FIND v(dout1_2) AT=570.05n

.meas tran vdout1_3ck560 FIND v(dout1_3) AT=570.05n

.meas tran vdout1_4ck560 FIND v(dout1_4) AT=570.05n

.meas tran vdout1_5ck560 FIND v(dout1_5) AT=570.05n

.meas tran vdout1_6ck560 FIND v(dout1_6) AT=570.05n

.meas tran vdout1_7ck560 FIND v(dout1_7) AT=570.05n

.meas tran vdout1_0ck570 FIND v(dout1_0) AT=580.05n

.meas tran vdout1_1ck570 FIND v(dout1_1) AT=580.05n

.meas tran vdout1_2ck570 FIND v(dout1_2) AT=580.05n

.meas tran vdout1_3ck570 FIND v(dout1_3) AT=580.05n

.meas tran vdout1_4ck570 FIND v(dout1_4) AT=580.05n

.meas tran vdout1_5ck570 FIND v(dout1_5) AT=580.05n

.meas tran vdout1_6ck570 FIND v(dout1_6) AT=580.05n

.meas tran vdout1_7ck570 FIND v(dout1_7) AT=580.05n

.meas tran vdout1_0ck580 FIND v(dout1_0) AT=590.05n

.meas tran vdout1_1ck580 FIND v(dout1_1) AT=590.05n

.meas tran vdout1_2ck580 FIND v(dout1_2) AT=590.05n

.meas tran vdout1_3ck580 FIND v(dout1_3) AT=590.05n

.meas tran vdout1_4ck580 FIND v(dout1_4) AT=590.05n

.meas tran vdout1_5ck580 FIND v(dout1_5) AT=590.05n

.meas tran vdout1_6ck580 FIND v(dout1_6) AT=590.05n

.meas tran vdout1_7ck580 FIND v(dout1_7) AT=590.05n

.meas tran vdout1_0ck630 FIND v(dout1_0) AT=640.05n

.meas tran vdout1_1ck630 FIND v(dout1_1) AT=640.05n

.meas tran vdout1_2ck630 FIND v(dout1_2) AT=640.05n

.meas tran vdout1_3ck630 FIND v(dout1_3) AT=640.05n

.meas tran vdout1_4ck630 FIND v(dout1_4) AT=640.05n

.meas tran vdout1_5ck630 FIND v(dout1_5) AT=640.05n

.meas tran vdout1_6ck630 FIND v(dout1_6) AT=640.05n

.meas tran vdout1_7ck630 FIND v(dout1_7) AT=640.05n

.meas tran vdout1_0ck640 FIND v(dout1_0) AT=650.05n

.meas tran vdout1_1ck640 FIND v(dout1_1) AT=650.05n

.meas tran vdout1_2ck640 FIND v(dout1_2) AT=650.05n

.meas tran vdout1_3ck640 FIND v(dout1_3) AT=650.05n

.meas tran vdout1_4ck640 FIND v(dout1_4) AT=650.05n

.meas tran vdout1_5ck640 FIND v(dout1_5) AT=650.05n

.meas tran vdout1_6ck640 FIND v(dout1_6) AT=650.05n

.meas tran vdout1_7ck640 FIND v(dout1_7) AT=650.05n

.meas tran vdout1_0ck710 FIND v(dout1_0) AT=720.05n

.meas tran vdout1_1ck710 FIND v(dout1_1) AT=720.05n

.meas tran vdout1_2ck710 FIND v(dout1_2) AT=720.05n

.meas tran vdout1_3ck710 FIND v(dout1_3) AT=720.05n

.meas tran vdout1_4ck710 FIND v(dout1_4) AT=720.05n

.meas tran vdout1_5ck710 FIND v(dout1_5) AT=720.05n

.meas tran vdout1_6ck710 FIND v(dout1_6) AT=720.05n

.meas tran vdout1_7ck710 FIND v(dout1_7) AT=720.05n

.meas tran vdout1_0ck750 FIND v(dout1_0) AT=760.05n

.meas tran vdout1_1ck750 FIND v(dout1_1) AT=760.05n

.meas tran vdout1_2ck750 FIND v(dout1_2) AT=760.05n

.meas tran vdout1_3ck750 FIND v(dout1_3) AT=760.05n

.meas tran vdout1_4ck750 FIND v(dout1_4) AT=760.05n

.meas tran vdout1_5ck750 FIND v(dout1_5) AT=760.05n

.meas tran vdout1_6ck750 FIND v(dout1_6) AT=760.05n

.meas tran vdout1_7ck750 FIND v(dout1_7) AT=760.05n

.meas tran vdout1_0ck770 FIND v(dout1_0) AT=780.05n

.meas tran vdout1_1ck770 FIND v(dout1_1) AT=780.05n

.meas tran vdout1_2ck770 FIND v(dout1_2) AT=780.05n

.meas tran vdout1_3ck770 FIND v(dout1_3) AT=780.05n

.meas tran vdout1_4ck770 FIND v(dout1_4) AT=780.05n

.meas tran vdout1_5ck770 FIND v(dout1_5) AT=780.05n

.meas tran vdout1_6ck770 FIND v(dout1_6) AT=780.05n

.meas tran vdout1_7ck770 FIND v(dout1_7) AT=780.05n

.meas tran vdout1_0ck840 FIND v(dout1_0) AT=850.05n

.meas tran vdout1_1ck840 FIND v(dout1_1) AT=850.05n

.meas tran vdout1_2ck840 FIND v(dout1_2) AT=850.05n

.meas tran vdout1_3ck840 FIND v(dout1_3) AT=850.05n

.meas tran vdout1_4ck840 FIND v(dout1_4) AT=850.05n

.meas tran vdout1_5ck840 FIND v(dout1_5) AT=850.05n

.meas tran vdout1_6ck840 FIND v(dout1_6) AT=850.05n

.meas tran vdout1_7ck840 FIND v(dout1_7) AT=850.05n

.meas tran vdout1_0ck880 FIND v(dout1_0) AT=890.05n

.meas tran vdout1_1ck880 FIND v(dout1_1) AT=890.05n

.meas tran vdout1_2ck880 FIND v(dout1_2) AT=890.05n

.meas tran vdout1_3ck880 FIND v(dout1_3) AT=890.05n

.meas tran vdout1_4ck880 FIND v(dout1_4) AT=890.05n

.meas tran vdout1_5ck880 FIND v(dout1_5) AT=890.05n

.meas tran vdout1_6ck880 FIND v(dout1_6) AT=890.05n

.meas tran vdout1_7ck880 FIND v(dout1_7) AT=890.05n

.meas tran vdout1_0ck890 FIND v(dout1_0) AT=900.05n

.meas tran vdout1_1ck890 FIND v(dout1_1) AT=900.05n

.meas tran vdout1_2ck890 FIND v(dout1_2) AT=900.05n

.meas tran vdout1_3ck890 FIND v(dout1_3) AT=900.05n

.meas tran vdout1_4ck890 FIND v(dout1_4) AT=900.05n

.meas tran vdout1_5ck890 FIND v(dout1_5) AT=900.05n

.meas tran vdout1_6ck890 FIND v(dout1_6) AT=900.05n

.meas tran vdout1_7ck890 FIND v(dout1_7) AT=900.05n

.meas tran vdout1_0ck900 FIND v(dout1_0) AT=910.05n

.meas tran vdout1_1ck900 FIND v(dout1_1) AT=910.05n

.meas tran vdout1_2ck900 FIND v(dout1_2) AT=910.05n

.meas tran vdout1_3ck900 FIND v(dout1_3) AT=910.05n

.meas tran vdout1_4ck900 FIND v(dout1_4) AT=910.05n

.meas tran vdout1_5ck900 FIND v(dout1_5) AT=910.05n

.meas tran vdout1_6ck900 FIND v(dout1_6) AT=910.05n

.meas tran vdout1_7ck900 FIND v(dout1_7) AT=910.05n

.meas tran vdout1_0ck910 FIND v(dout1_0) AT=920.05n

.meas tran vdout1_1ck910 FIND v(dout1_1) AT=920.05n

.meas tran vdout1_2ck910 FIND v(dout1_2) AT=920.05n

.meas tran vdout1_3ck910 FIND v(dout1_3) AT=920.05n

.meas tran vdout1_4ck910 FIND v(dout1_4) AT=920.05n

.meas tran vdout1_5ck910 FIND v(dout1_5) AT=920.05n

.meas tran vdout1_6ck910 FIND v(dout1_6) AT=920.05n

.meas tran vdout1_7ck910 FIND v(dout1_7) AT=920.05n

.meas tran vdout1_0ck940 FIND v(dout1_0) AT=950.05n

.meas tran vdout1_1ck940 FIND v(dout1_1) AT=950.05n

.meas tran vdout1_2ck940 FIND v(dout1_2) AT=950.05n

.meas tran vdout1_3ck940 FIND v(dout1_3) AT=950.05n

.meas tran vdout1_4ck940 FIND v(dout1_4) AT=950.05n

.meas tran vdout1_5ck940 FIND v(dout1_5) AT=950.05n

.meas tran vdout1_6ck940 FIND v(dout1_6) AT=950.05n

.meas tran vdout1_7ck940 FIND v(dout1_7) AT=950.05n

.meas tran vdout1_0ck980 FIND v(dout1_0) AT=990.05n

.meas tran vdout1_1ck980 FIND v(dout1_1) AT=990.05n

.meas tran vdout1_2ck980 FIND v(dout1_2) AT=990.05n

.meas tran vdout1_3ck980 FIND v(dout1_3) AT=990.05n

.meas tran vdout1_4ck980 FIND v(dout1_4) AT=990.05n

.meas tran vdout1_5ck980 FIND v(dout1_5) AT=990.05n

.meas tran vdout1_6ck980 FIND v(dout1_6) AT=990.05n

.meas tran vdout1_7ck980 FIND v(dout1_7) AT=990.05n

.meas tran vdout1_0ck1000 FIND v(dout1_0) AT=1010.05n

.meas tran vdout1_1ck1000 FIND v(dout1_1) AT=1010.05n

.meas tran vdout1_2ck1000 FIND v(dout1_2) AT=1010.05n

.meas tran vdout1_3ck1000 FIND v(dout1_3) AT=1010.05n

.meas tran vdout1_4ck1000 FIND v(dout1_4) AT=1010.05n

.meas tran vdout1_5ck1000 FIND v(dout1_5) AT=1010.05n

.meas tran vdout1_6ck1000 FIND v(dout1_6) AT=1010.05n

.meas tran vdout1_7ck1000 FIND v(dout1_7) AT=1010.05n

.meas tran vdout1_0ck1010 FIND v(dout1_0) AT=1020.05n

.meas tran vdout1_1ck1010 FIND v(dout1_1) AT=1020.05n

.meas tran vdout1_2ck1010 FIND v(dout1_2) AT=1020.05n

.meas tran vdout1_3ck1010 FIND v(dout1_3) AT=1020.05n

.meas tran vdout1_4ck1010 FIND v(dout1_4) AT=1020.05n

.meas tran vdout1_5ck1010 FIND v(dout1_5) AT=1020.05n

.meas tran vdout1_6ck1010 FIND v(dout1_6) AT=1020.05n

.meas tran vdout1_7ck1010 FIND v(dout1_7) AT=1020.05n

.meas tran vdout1_0ck1050 FIND v(dout1_0) AT=1060.05n

.meas tran vdout1_1ck1050 FIND v(dout1_1) AT=1060.05n

.meas tran vdout1_2ck1050 FIND v(dout1_2) AT=1060.05n

.meas tran vdout1_3ck1050 FIND v(dout1_3) AT=1060.05n

.meas tran vdout1_4ck1050 FIND v(dout1_4) AT=1060.05n

.meas tran vdout1_5ck1050 FIND v(dout1_5) AT=1060.05n

.meas tran vdout1_6ck1050 FIND v(dout1_6) AT=1060.05n

.meas tran vdout1_7ck1050 FIND v(dout1_7) AT=1060.05n

.meas tran vdout1_0ck1060 FIND v(dout1_0) AT=1070.05n

.meas tran vdout1_1ck1060 FIND v(dout1_1) AT=1070.05n

.meas tran vdout1_2ck1060 FIND v(dout1_2) AT=1070.05n

.meas tran vdout1_3ck1060 FIND v(dout1_3) AT=1070.05n

.meas tran vdout1_4ck1060 FIND v(dout1_4) AT=1070.05n

.meas tran vdout1_5ck1060 FIND v(dout1_5) AT=1070.05n

.meas tran vdout1_6ck1060 FIND v(dout1_6) AT=1070.05n

.meas tran vdout1_7ck1060 FIND v(dout1_7) AT=1070.05n

.meas tran vdout1_0ck1080 FIND v(dout1_0) AT=1090.05n

.meas tran vdout1_1ck1080 FIND v(dout1_1) AT=1090.05n

.meas tran vdout1_2ck1080 FIND v(dout1_2) AT=1090.05n

.meas tran vdout1_3ck1080 FIND v(dout1_3) AT=1090.05n

.meas tran vdout1_4ck1080 FIND v(dout1_4) AT=1090.05n

.meas tran vdout1_5ck1080 FIND v(dout1_5) AT=1090.05n

.meas tran vdout1_6ck1080 FIND v(dout1_6) AT=1090.05n

.meas tran vdout1_7ck1080 FIND v(dout1_7) AT=1090.05n

.meas tran vdout1_0ck1130 FIND v(dout1_0) AT=1140.05n

.meas tran vdout1_1ck1130 FIND v(dout1_1) AT=1140.05n

.meas tran vdout1_2ck1130 FIND v(dout1_2) AT=1140.05n

.meas tran vdout1_3ck1130 FIND v(dout1_3) AT=1140.05n

.meas tran vdout1_4ck1130 FIND v(dout1_4) AT=1140.05n

.meas tran vdout1_5ck1130 FIND v(dout1_5) AT=1140.05n

.meas tran vdout1_6ck1130 FIND v(dout1_6) AT=1140.05n

.meas tran vdout1_7ck1130 FIND v(dout1_7) AT=1140.05n

.meas tran vdout1_0ck1190 FIND v(dout1_0) AT=1200.05n

.meas tran vdout1_1ck1190 FIND v(dout1_1) AT=1200.05n

.meas tran vdout1_2ck1190 FIND v(dout1_2) AT=1200.05n

.meas tran vdout1_3ck1190 FIND v(dout1_3) AT=1200.05n

.meas tran vdout1_4ck1190 FIND v(dout1_4) AT=1200.05n

.meas tran vdout1_5ck1190 FIND v(dout1_5) AT=1200.05n

.meas tran vdout1_6ck1190 FIND v(dout1_6) AT=1200.05n

.meas tran vdout1_7ck1190 FIND v(dout1_7) AT=1200.05n

.meas tran vdout1_0ck1200 FIND v(dout1_0) AT=1210.05n

.meas tran vdout1_1ck1200 FIND v(dout1_1) AT=1210.05n

.meas tran vdout1_2ck1200 FIND v(dout1_2) AT=1210.05n

.meas tran vdout1_3ck1200 FIND v(dout1_3) AT=1210.05n

.meas tran vdout1_4ck1200 FIND v(dout1_4) AT=1210.05n

.meas tran vdout1_5ck1200 FIND v(dout1_5) AT=1210.05n

.meas tran vdout1_6ck1200 FIND v(dout1_6) AT=1210.05n

.meas tran vdout1_7ck1200 FIND v(dout1_7) AT=1210.05n

.meas tran vdout1_0ck1210 FIND v(dout1_0) AT=1220.05n

.meas tran vdout1_1ck1210 FIND v(dout1_1) AT=1220.05n

.meas tran vdout1_2ck1210 FIND v(dout1_2) AT=1220.05n

.meas tran vdout1_3ck1210 FIND v(dout1_3) AT=1220.05n

.meas tran vdout1_4ck1210 FIND v(dout1_4) AT=1220.05n

.meas tran vdout1_5ck1210 FIND v(dout1_5) AT=1220.05n

.meas tran vdout1_6ck1210 FIND v(dout1_6) AT=1220.05n

.meas tran vdout1_7ck1210 FIND v(dout1_7) AT=1220.05n

.meas tran vdout1_0ck1220 FIND v(dout1_0) AT=1230.05n

.meas tran vdout1_1ck1220 FIND v(dout1_1) AT=1230.05n

.meas tran vdout1_2ck1220 FIND v(dout1_2) AT=1230.05n

.meas tran vdout1_3ck1220 FIND v(dout1_3) AT=1230.05n

.meas tran vdout1_4ck1220 FIND v(dout1_4) AT=1230.05n

.meas tran vdout1_5ck1220 FIND v(dout1_5) AT=1230.05n

.meas tran vdout1_6ck1220 FIND v(dout1_6) AT=1230.05n

.meas tran vdout1_7ck1220 FIND v(dout1_7) AT=1230.05n

.meas tran vdout1_0ck1230 FIND v(dout1_0) AT=1240.05n

.meas tran vdout1_1ck1230 FIND v(dout1_1) AT=1240.05n

.meas tran vdout1_2ck1230 FIND v(dout1_2) AT=1240.05n

.meas tran vdout1_3ck1230 FIND v(dout1_3) AT=1240.05n

.meas tran vdout1_4ck1230 FIND v(dout1_4) AT=1240.05n

.meas tran vdout1_5ck1230 FIND v(dout1_5) AT=1240.05n

.meas tran vdout1_6ck1230 FIND v(dout1_6) AT=1240.05n

.meas tran vdout1_7ck1230 FIND v(dout1_7) AT=1240.05n

.meas tran vdout1_0ck1250 FIND v(dout1_0) AT=1260.05n

.meas tran vdout1_1ck1250 FIND v(dout1_1) AT=1260.05n

.meas tran vdout1_2ck1250 FIND v(dout1_2) AT=1260.05n

.meas tran vdout1_3ck1250 FIND v(dout1_3) AT=1260.05n

.meas tran vdout1_4ck1250 FIND v(dout1_4) AT=1260.05n

.meas tran vdout1_5ck1250 FIND v(dout1_5) AT=1260.05n

.meas tran vdout1_6ck1250 FIND v(dout1_6) AT=1260.05n

.meas tran vdout1_7ck1250 FIND v(dout1_7) AT=1260.05n

.meas tran vdout1_0ck1340 FIND v(dout1_0) AT=1350.05n

.meas tran vdout1_1ck1340 FIND v(dout1_1) AT=1350.05n

.meas tran vdout1_2ck1340 FIND v(dout1_2) AT=1350.05n

.meas tran vdout1_3ck1340 FIND v(dout1_3) AT=1350.05n

.meas tran vdout1_4ck1340 FIND v(dout1_4) AT=1350.05n

.meas tran vdout1_5ck1340 FIND v(dout1_5) AT=1350.05n

.meas tran vdout1_6ck1340 FIND v(dout1_6) AT=1350.05n

.meas tran vdout1_7ck1340 FIND v(dout1_7) AT=1350.05n

.meas tran vdout1_0ck1370 FIND v(dout1_0) AT=1380.05n

.meas tran vdout1_1ck1370 FIND v(dout1_1) AT=1380.05n

.meas tran vdout1_2ck1370 FIND v(dout1_2) AT=1380.05n

.meas tran vdout1_3ck1370 FIND v(dout1_3) AT=1380.05n

.meas tran vdout1_4ck1370 FIND v(dout1_4) AT=1380.05n

.meas tran vdout1_5ck1370 FIND v(dout1_5) AT=1380.05n

.meas tran vdout1_6ck1370 FIND v(dout1_6) AT=1380.05n

.meas tran vdout1_7ck1370 FIND v(dout1_7) AT=1380.05n

.meas tran vdout1_0ck1380 FIND v(dout1_0) AT=1390.05n

.meas tran vdout1_1ck1380 FIND v(dout1_1) AT=1390.05n

.meas tran vdout1_2ck1380 FIND v(dout1_2) AT=1390.05n

.meas tran vdout1_3ck1380 FIND v(dout1_3) AT=1390.05n

.meas tran vdout1_4ck1380 FIND v(dout1_4) AT=1390.05n

.meas tran vdout1_5ck1380 FIND v(dout1_5) AT=1390.05n

.meas tran vdout1_6ck1380 FIND v(dout1_6) AT=1390.05n

.meas tran vdout1_7ck1380 FIND v(dout1_7) AT=1390.05n

.meas tran vdout1_0ck1430 FIND v(dout1_0) AT=1440.05n

.meas tran vdout1_1ck1430 FIND v(dout1_1) AT=1440.05n

.meas tran vdout1_2ck1430 FIND v(dout1_2) AT=1440.05n

.meas tran vdout1_3ck1430 FIND v(dout1_3) AT=1440.05n

.meas tran vdout1_4ck1430 FIND v(dout1_4) AT=1440.05n

.meas tran vdout1_5ck1430 FIND v(dout1_5) AT=1440.05n

.meas tran vdout1_6ck1430 FIND v(dout1_6) AT=1440.05n

.meas tran vdout1_7ck1430 FIND v(dout1_7) AT=1440.05n

.meas tran vdout1_0ck1460 FIND v(dout1_0) AT=1470.05n

.meas tran vdout1_1ck1460 FIND v(dout1_1) AT=1470.05n

.meas tran vdout1_2ck1460 FIND v(dout1_2) AT=1470.05n

.meas tran vdout1_3ck1460 FIND v(dout1_3) AT=1470.05n

.meas tran vdout1_4ck1460 FIND v(dout1_4) AT=1470.05n

.meas tran vdout1_5ck1460 FIND v(dout1_5) AT=1470.05n

.meas tran vdout1_6ck1460 FIND v(dout1_6) AT=1470.05n

.meas tran vdout1_7ck1460 FIND v(dout1_7) AT=1470.05n

.meas tran vdout1_0ck1570 FIND v(dout1_0) AT=1580.05n

.meas tran vdout1_1ck1570 FIND v(dout1_1) AT=1580.05n

.meas tran vdout1_2ck1570 FIND v(dout1_2) AT=1580.05n

.meas tran vdout1_3ck1570 FIND v(dout1_3) AT=1580.05n

.meas tran vdout1_4ck1570 FIND v(dout1_4) AT=1580.05n

.meas tran vdout1_5ck1570 FIND v(dout1_5) AT=1580.05n

.meas tran vdout1_6ck1570 FIND v(dout1_6) AT=1580.05n

.meas tran vdout1_7ck1570 FIND v(dout1_7) AT=1580.05n

.meas tran vdout1_0ck1580 FIND v(dout1_0) AT=1590.05n

.meas tran vdout1_1ck1580 FIND v(dout1_1) AT=1590.05n

.meas tran vdout1_2ck1580 FIND v(dout1_2) AT=1590.05n

.meas tran vdout1_3ck1580 FIND v(dout1_3) AT=1590.05n

.meas tran vdout1_4ck1580 FIND v(dout1_4) AT=1590.05n

.meas tran vdout1_5ck1580 FIND v(dout1_5) AT=1590.05n

.meas tran vdout1_6ck1580 FIND v(dout1_6) AT=1590.05n

.meas tran vdout1_7ck1580 FIND v(dout1_7) AT=1590.05n

.meas tran vdout1_0ck1670 FIND v(dout1_0) AT=1680.05n

.meas tran vdout1_1ck1670 FIND v(dout1_1) AT=1680.05n

.meas tran vdout1_2ck1670 FIND v(dout1_2) AT=1680.05n

.meas tran vdout1_3ck1670 FIND v(dout1_3) AT=1680.05n

.meas tran vdout1_4ck1670 FIND v(dout1_4) AT=1680.05n

.meas tran vdout1_5ck1670 FIND v(dout1_5) AT=1680.05n

.meas tran vdout1_6ck1670 FIND v(dout1_6) AT=1680.05n

.meas tran vdout1_7ck1670 FIND v(dout1_7) AT=1680.05n

.meas tran vdout1_0ck1700 FIND v(dout1_0) AT=1710.05n

.meas tran vdout1_1ck1700 FIND v(dout1_1) AT=1710.05n

.meas tran vdout1_2ck1700 FIND v(dout1_2) AT=1710.05n

.meas tran vdout1_3ck1700 FIND v(dout1_3) AT=1710.05n

.meas tran vdout1_4ck1700 FIND v(dout1_4) AT=1710.05n

.meas tran vdout1_5ck1700 FIND v(dout1_5) AT=1710.05n

.meas tran vdout1_6ck1700 FIND v(dout1_6) AT=1710.05n

.meas tran vdout1_7ck1700 FIND v(dout1_7) AT=1710.05n

.meas tran vdout1_0ck1720 FIND v(dout1_0) AT=1730.05n

.meas tran vdout1_1ck1720 FIND v(dout1_1) AT=1730.05n

.meas tran vdout1_2ck1720 FIND v(dout1_2) AT=1730.05n

.meas tran vdout1_3ck1720 FIND v(dout1_3) AT=1730.05n

.meas tran vdout1_4ck1720 FIND v(dout1_4) AT=1730.05n

.meas tran vdout1_5ck1720 FIND v(dout1_5) AT=1730.05n

.meas tran vdout1_6ck1720 FIND v(dout1_6) AT=1730.05n

.meas tran vdout1_7ck1720 FIND v(dout1_7) AT=1730.05n

.meas tran vdout1_0ck1740 FIND v(dout1_0) AT=1750.05n

.meas tran vdout1_1ck1740 FIND v(dout1_1) AT=1750.05n

.meas tran vdout1_2ck1740 FIND v(dout1_2) AT=1750.05n

.meas tran vdout1_3ck1740 FIND v(dout1_3) AT=1750.05n

.meas tran vdout1_4ck1740 FIND v(dout1_4) AT=1750.05n

.meas tran vdout1_5ck1740 FIND v(dout1_5) AT=1750.05n

.meas tran vdout1_6ck1740 FIND v(dout1_6) AT=1750.05n

.meas tran vdout1_7ck1740 FIND v(dout1_7) AT=1750.05n

.meas tran vdout1_0ck1760 FIND v(dout1_0) AT=1770.05n

.meas tran vdout1_1ck1760 FIND v(dout1_1) AT=1770.05n

.meas tran vdout1_2ck1760 FIND v(dout1_2) AT=1770.05n

.meas tran vdout1_3ck1760 FIND v(dout1_3) AT=1770.05n

.meas tran vdout1_4ck1760 FIND v(dout1_4) AT=1770.05n

.meas tran vdout1_5ck1760 FIND v(dout1_5) AT=1770.05n

.meas tran vdout1_6ck1760 FIND v(dout1_6) AT=1770.05n

.meas tran vdout1_7ck1760 FIND v(dout1_7) AT=1770.05n

.meas tran vdout1_0ck1790 FIND v(dout1_0) AT=1800.05n

.meas tran vdout1_1ck1790 FIND v(dout1_1) AT=1800.05n

.meas tran vdout1_2ck1790 FIND v(dout1_2) AT=1800.05n

.meas tran vdout1_3ck1790 FIND v(dout1_3) AT=1800.05n

.meas tran vdout1_4ck1790 FIND v(dout1_4) AT=1800.05n

.meas tran vdout1_5ck1790 FIND v(dout1_5) AT=1800.05n

.meas tran vdout1_6ck1790 FIND v(dout1_6) AT=1800.05n

.meas tran vdout1_7ck1790 FIND v(dout1_7) AT=1800.05n

.meas tran vdout1_0ck1800 FIND v(dout1_0) AT=1810.05n

.meas tran vdout1_1ck1800 FIND v(dout1_1) AT=1810.05n

.meas tran vdout1_2ck1800 FIND v(dout1_2) AT=1810.05n

.meas tran vdout1_3ck1800 FIND v(dout1_3) AT=1810.05n

.meas tran vdout1_4ck1800 FIND v(dout1_4) AT=1810.05n

.meas tran vdout1_5ck1800 FIND v(dout1_5) AT=1810.05n

.meas tran vdout1_6ck1800 FIND v(dout1_6) AT=1810.05n

.meas tran vdout1_7ck1800 FIND v(dout1_7) AT=1810.05n

.meas tran vdout1_0ck1840 FIND v(dout1_0) AT=1850.05n

.meas tran vdout1_1ck1840 FIND v(dout1_1) AT=1850.05n

.meas tran vdout1_2ck1840 FIND v(dout1_2) AT=1850.05n

.meas tran vdout1_3ck1840 FIND v(dout1_3) AT=1850.05n

.meas tran vdout1_4ck1840 FIND v(dout1_4) AT=1850.05n

.meas tran vdout1_5ck1840 FIND v(dout1_5) AT=1850.05n

.meas tran vdout1_6ck1840 FIND v(dout1_6) AT=1850.05n

.meas tran vdout1_7ck1840 FIND v(dout1_7) AT=1850.05n

.meas tran vdout1_0ck1900 FIND v(dout1_0) AT=1910.05n

.meas tran vdout1_1ck1900 FIND v(dout1_1) AT=1910.05n

.meas tran vdout1_2ck1900 FIND v(dout1_2) AT=1910.05n

.meas tran vdout1_3ck1900 FIND v(dout1_3) AT=1910.05n

.meas tran vdout1_4ck1900 FIND v(dout1_4) AT=1910.05n

.meas tran vdout1_5ck1900 FIND v(dout1_5) AT=1910.05n

.meas tran vdout1_6ck1900 FIND v(dout1_6) AT=1910.05n

.meas tran vdout1_7ck1900 FIND v(dout1_7) AT=1910.05n

.meas tran vdout1_0ck1950 FIND v(dout1_0) AT=1960.05n

.meas tran vdout1_1ck1950 FIND v(dout1_1) AT=1960.05n

.meas tran vdout1_2ck1950 FIND v(dout1_2) AT=1960.05n

.meas tran vdout1_3ck1950 FIND v(dout1_3) AT=1960.05n

.meas tran vdout1_4ck1950 FIND v(dout1_4) AT=1960.05n

.meas tran vdout1_5ck1950 FIND v(dout1_5) AT=1960.05n

.meas tran vdout1_6ck1950 FIND v(dout1_6) AT=1960.05n

.meas tran vdout1_7ck1950 FIND v(dout1_7) AT=1960.05n

.meas tran vdout1_0ck1960 FIND v(dout1_0) AT=1970.05n

.meas tran vdout1_1ck1960 FIND v(dout1_1) AT=1970.05n

.meas tran vdout1_2ck1960 FIND v(dout1_2) AT=1970.05n

.meas tran vdout1_3ck1960 FIND v(dout1_3) AT=1970.05n

.meas tran vdout1_4ck1960 FIND v(dout1_4) AT=1970.05n

.meas tran vdout1_5ck1960 FIND v(dout1_5) AT=1970.05n

.meas tran vdout1_6ck1960 FIND v(dout1_6) AT=1970.05n

.meas tran vdout1_7ck1960 FIND v(dout1_7) AT=1970.05n

.meas tran vdout1_0ck1980 FIND v(dout1_0) AT=1990.05n

.meas tran vdout1_1ck1980 FIND v(dout1_1) AT=1990.05n

.meas tran vdout1_2ck1980 FIND v(dout1_2) AT=1990.05n

.meas tran vdout1_3ck1980 FIND v(dout1_3) AT=1990.05n

.meas tran vdout1_4ck1980 FIND v(dout1_4) AT=1990.05n

.meas tran vdout1_5ck1980 FIND v(dout1_5) AT=1990.05n

.meas tran vdout1_6ck1980 FIND v(dout1_6) AT=1990.05n

.meas tran vdout1_7ck1980 FIND v(dout1_7) AT=1990.05n

.meas tran vdout1_0ck1990 FIND v(dout1_0) AT=2000.05n

.meas tran vdout1_1ck1990 FIND v(dout1_1) AT=2000.05n

.meas tran vdout1_2ck1990 FIND v(dout1_2) AT=2000.05n

.meas tran vdout1_3ck1990 FIND v(dout1_3) AT=2000.05n

.meas tran vdout1_4ck1990 FIND v(dout1_4) AT=2000.05n

.meas tran vdout1_5ck1990 FIND v(dout1_5) AT=2000.05n

.meas tran vdout1_6ck1990 FIND v(dout1_6) AT=2000.05n

.meas tran vdout1_7ck1990 FIND v(dout1_7) AT=2000.05n

.meas tran vdout1_0ck2020 FIND v(dout1_0) AT=2030.05n

.meas tran vdout1_1ck2020 FIND v(dout1_1) AT=2030.05n

.meas tran vdout1_2ck2020 FIND v(dout1_2) AT=2030.05n

.meas tran vdout1_3ck2020 FIND v(dout1_3) AT=2030.05n

.meas tran vdout1_4ck2020 FIND v(dout1_4) AT=2030.05n

.meas tran vdout1_5ck2020 FIND v(dout1_5) AT=2030.05n

.meas tran vdout1_6ck2020 FIND v(dout1_6) AT=2030.05n

.meas tran vdout1_7ck2020 FIND v(dout1_7) AT=2030.05n

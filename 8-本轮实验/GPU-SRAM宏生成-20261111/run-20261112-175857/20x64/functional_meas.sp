.meas tran vdout1_0ck40 FIND v(dout1_0) AT=50.05n

.meas tran vdout1_1ck40 FIND v(dout1_1) AT=50.05n

.meas tran vdout1_2ck40 FIND v(dout1_2) AT=50.05n

.meas tran vdout1_3ck40 FIND v(dout1_3) AT=50.05n

.meas tran vdout1_4ck40 FIND v(dout1_4) AT=50.05n

.meas tran vdout1_5ck40 FIND v(dout1_5) AT=50.05n

.meas tran vdout1_6ck40 FIND v(dout1_6) AT=50.05n

.meas tran vdout1_7ck40 FIND v(dout1_7) AT=50.05n

.meas tran vdout1_8ck40 FIND v(dout1_8) AT=50.05n

.meas tran vdout1_9ck40 FIND v(dout1_9) AT=50.05n

.meas tran vdout1_10ck40 FIND v(dout1_10) AT=50.05n

.meas tran vdout1_11ck40 FIND v(dout1_11) AT=50.05n

.meas tran vdout1_12ck40 FIND v(dout1_12) AT=50.05n

.meas tran vdout1_13ck40 FIND v(dout1_13) AT=50.05n

.meas tran vdout1_14ck40 FIND v(dout1_14) AT=50.05n

.meas tran vdout1_15ck40 FIND v(dout1_15) AT=50.05n

.meas tran vdout1_16ck40 FIND v(dout1_16) AT=50.05n

.meas tran vdout1_17ck40 FIND v(dout1_17) AT=50.05n

.meas tran vdout1_18ck40 FIND v(dout1_18) AT=50.05n

.meas tran vdout1_19ck40 FIND v(dout1_19) AT=50.05n

.meas tran vdout1_0ck170 FIND v(dout1_0) AT=180.05n

.meas tran vdout1_1ck170 FIND v(dout1_1) AT=180.05n

.meas tran vdout1_2ck170 FIND v(dout1_2) AT=180.05n

.meas tran vdout1_3ck170 FIND v(dout1_3) AT=180.05n

.meas tran vdout1_4ck170 FIND v(dout1_4) AT=180.05n

.meas tran vdout1_5ck170 FIND v(dout1_5) AT=180.05n

.meas tran vdout1_6ck170 FIND v(dout1_6) AT=180.05n

.meas tran vdout1_7ck170 FIND v(dout1_7) AT=180.05n

.meas tran vdout1_8ck170 FIND v(dout1_8) AT=180.05n

.meas tran vdout1_9ck170 FIND v(dout1_9) AT=180.05n

.meas tran vdout1_10ck170 FIND v(dout1_10) AT=180.05n

.meas tran vdout1_11ck170 FIND v(dout1_11) AT=180.05n

.meas tran vdout1_12ck170 FIND v(dout1_12) AT=180.05n

.meas tran vdout1_13ck170 FIND v(dout1_13) AT=180.05n

.meas tran vdout1_14ck170 FIND v(dout1_14) AT=180.05n

.meas tran vdout1_15ck170 FIND v(dout1_15) AT=180.05n

.meas tran vdout1_16ck170 FIND v(dout1_16) AT=180.05n

.meas tran vdout1_17ck170 FIND v(dout1_17) AT=180.05n

.meas tran vdout1_18ck170 FIND v(dout1_18) AT=180.05n

.meas tran vdout1_19ck170 FIND v(dout1_19) AT=180.05n

.meas tran vdout1_0ck180 FIND v(dout1_0) AT=190.05n

.meas tran vdout1_1ck180 FIND v(dout1_1) AT=190.05n

.meas tran vdout1_2ck180 FIND v(dout1_2) AT=190.05n

.meas tran vdout1_3ck180 FIND v(dout1_3) AT=190.05n

.meas tran vdout1_4ck180 FIND v(dout1_4) AT=190.05n

.meas tran vdout1_5ck180 FIND v(dout1_5) AT=190.05n

.meas tran vdout1_6ck180 FIND v(dout1_6) AT=190.05n

.meas tran vdout1_7ck180 FIND v(dout1_7) AT=190.05n

.meas tran vdout1_8ck180 FIND v(dout1_8) AT=190.05n

.meas tran vdout1_9ck180 FIND v(dout1_9) AT=190.05n

.meas tran vdout1_10ck180 FIND v(dout1_10) AT=190.05n

.meas tran vdout1_11ck180 FIND v(dout1_11) AT=190.05n

.meas tran vdout1_12ck180 FIND v(dout1_12) AT=190.05n

.meas tran vdout1_13ck180 FIND v(dout1_13) AT=190.05n

.meas tran vdout1_14ck180 FIND v(dout1_14) AT=190.05n

.meas tran vdout1_15ck180 FIND v(dout1_15) AT=190.05n

.meas tran vdout1_16ck180 FIND v(dout1_16) AT=190.05n

.meas tran vdout1_17ck180 FIND v(dout1_17) AT=190.05n

.meas tran vdout1_18ck180 FIND v(dout1_18) AT=190.05n

.meas tran vdout1_19ck180 FIND v(dout1_19) AT=190.05n

.meas tran vdout1_0ck230 FIND v(dout1_0) AT=240.05n

.meas tran vdout1_1ck230 FIND v(dout1_1) AT=240.05n

.meas tran vdout1_2ck230 FIND v(dout1_2) AT=240.05n

.meas tran vdout1_3ck230 FIND v(dout1_3) AT=240.05n

.meas tran vdout1_4ck230 FIND v(dout1_4) AT=240.05n

.meas tran vdout1_5ck230 FIND v(dout1_5) AT=240.05n

.meas tran vdout1_6ck230 FIND v(dout1_6) AT=240.05n

.meas tran vdout1_7ck230 FIND v(dout1_7) AT=240.05n

.meas tran vdout1_8ck230 FIND v(dout1_8) AT=240.05n

.meas tran vdout1_9ck230 FIND v(dout1_9) AT=240.05n

.meas tran vdout1_10ck230 FIND v(dout1_10) AT=240.05n

.meas tran vdout1_11ck230 FIND v(dout1_11) AT=240.05n

.meas tran vdout1_12ck230 FIND v(dout1_12) AT=240.05n

.meas tran vdout1_13ck230 FIND v(dout1_13) AT=240.05n

.meas tran vdout1_14ck230 FIND v(dout1_14) AT=240.05n

.meas tran vdout1_15ck230 FIND v(dout1_15) AT=240.05n

.meas tran vdout1_16ck230 FIND v(dout1_16) AT=240.05n

.meas tran vdout1_17ck230 FIND v(dout1_17) AT=240.05n

.meas tran vdout1_18ck230 FIND v(dout1_18) AT=240.05n

.meas tran vdout1_19ck230 FIND v(dout1_19) AT=240.05n

.meas tran vdout1_0ck260 FIND v(dout1_0) AT=270.05n

.meas tran vdout1_1ck260 FIND v(dout1_1) AT=270.05n

.meas tran vdout1_2ck260 FIND v(dout1_2) AT=270.05n

.meas tran vdout1_3ck260 FIND v(dout1_3) AT=270.05n

.meas tran vdout1_4ck260 FIND v(dout1_4) AT=270.05n

.meas tran vdout1_5ck260 FIND v(dout1_5) AT=270.05n

.meas tran vdout1_6ck260 FIND v(dout1_6) AT=270.05n

.meas tran vdout1_7ck260 FIND v(dout1_7) AT=270.05n

.meas tran vdout1_8ck260 FIND v(dout1_8) AT=270.05n

.meas tran vdout1_9ck260 FIND v(dout1_9) AT=270.05n

.meas tran vdout1_10ck260 FIND v(dout1_10) AT=270.05n

.meas tran vdout1_11ck260 FIND v(dout1_11) AT=270.05n

.meas tran vdout1_12ck260 FIND v(dout1_12) AT=270.05n

.meas tran vdout1_13ck260 FIND v(dout1_13) AT=270.05n

.meas tran vdout1_14ck260 FIND v(dout1_14) AT=270.05n

.meas tran vdout1_15ck260 FIND v(dout1_15) AT=270.05n

.meas tran vdout1_16ck260 FIND v(dout1_16) AT=270.05n

.meas tran vdout1_17ck260 FIND v(dout1_17) AT=270.05n

.meas tran vdout1_18ck260 FIND v(dout1_18) AT=270.05n

.meas tran vdout1_19ck260 FIND v(dout1_19) AT=270.05n

.meas tran vdout1_0ck290 FIND v(dout1_0) AT=300.05n

.meas tran vdout1_1ck290 FIND v(dout1_1) AT=300.05n

.meas tran vdout1_2ck290 FIND v(dout1_2) AT=300.05n

.meas tran vdout1_3ck290 FIND v(dout1_3) AT=300.05n

.meas tran vdout1_4ck290 FIND v(dout1_4) AT=300.05n

.meas tran vdout1_5ck290 FIND v(dout1_5) AT=300.05n

.meas tran vdout1_6ck290 FIND v(dout1_6) AT=300.05n

.meas tran vdout1_7ck290 FIND v(dout1_7) AT=300.05n

.meas tran vdout1_8ck290 FIND v(dout1_8) AT=300.05n

.meas tran vdout1_9ck290 FIND v(dout1_9) AT=300.05n

.meas tran vdout1_10ck290 FIND v(dout1_10) AT=300.05n

.meas tran vdout1_11ck290 FIND v(dout1_11) AT=300.05n

.meas tran vdout1_12ck290 FIND v(dout1_12) AT=300.05n

.meas tran vdout1_13ck290 FIND v(dout1_13) AT=300.05n

.meas tran vdout1_14ck290 FIND v(dout1_14) AT=300.05n

.meas tran vdout1_15ck290 FIND v(dout1_15) AT=300.05n

.meas tran vdout1_16ck290 FIND v(dout1_16) AT=300.05n

.meas tran vdout1_17ck290 FIND v(dout1_17) AT=300.05n

.meas tran vdout1_18ck290 FIND v(dout1_18) AT=300.05n

.meas tran vdout1_19ck290 FIND v(dout1_19) AT=300.05n

.meas tran vdout1_0ck310 FIND v(dout1_0) AT=320.05n

.meas tran vdout1_1ck310 FIND v(dout1_1) AT=320.05n

.meas tran vdout1_2ck310 FIND v(dout1_2) AT=320.05n

.meas tran vdout1_3ck310 FIND v(dout1_3) AT=320.05n

.meas tran vdout1_4ck310 FIND v(dout1_4) AT=320.05n

.meas tran vdout1_5ck310 FIND v(dout1_5) AT=320.05n

.meas tran vdout1_6ck310 FIND v(dout1_6) AT=320.05n

.meas tran vdout1_7ck310 FIND v(dout1_7) AT=320.05n

.meas tran vdout1_8ck310 FIND v(dout1_8) AT=320.05n

.meas tran vdout1_9ck310 FIND v(dout1_9) AT=320.05n

.meas tran vdout1_10ck310 FIND v(dout1_10) AT=320.05n

.meas tran vdout1_11ck310 FIND v(dout1_11) AT=320.05n

.meas tran vdout1_12ck310 FIND v(dout1_12) AT=320.05n

.meas tran vdout1_13ck310 FIND v(dout1_13) AT=320.05n

.meas tran vdout1_14ck310 FIND v(dout1_14) AT=320.05n

.meas tran vdout1_15ck310 FIND v(dout1_15) AT=320.05n

.meas tran vdout1_16ck310 FIND v(dout1_16) AT=320.05n

.meas tran vdout1_17ck310 FIND v(dout1_17) AT=320.05n

.meas tran vdout1_18ck310 FIND v(dout1_18) AT=320.05n

.meas tran vdout1_19ck310 FIND v(dout1_19) AT=320.05n

.meas tran vdout1_0ck340 FIND v(dout1_0) AT=350.05n

.meas tran vdout1_1ck340 FIND v(dout1_1) AT=350.05n

.meas tran vdout1_2ck340 FIND v(dout1_2) AT=350.05n

.meas tran vdout1_3ck340 FIND v(dout1_3) AT=350.05n

.meas tran vdout1_4ck340 FIND v(dout1_4) AT=350.05n

.meas tran vdout1_5ck340 FIND v(dout1_5) AT=350.05n

.meas tran vdout1_6ck340 FIND v(dout1_6) AT=350.05n

.meas tran vdout1_7ck340 FIND v(dout1_7) AT=350.05n

.meas tran vdout1_8ck340 FIND v(dout1_8) AT=350.05n

.meas tran vdout1_9ck340 FIND v(dout1_9) AT=350.05n

.meas tran vdout1_10ck340 FIND v(dout1_10) AT=350.05n

.meas tran vdout1_11ck340 FIND v(dout1_11) AT=350.05n

.meas tran vdout1_12ck340 FIND v(dout1_12) AT=350.05n

.meas tran vdout1_13ck340 FIND v(dout1_13) AT=350.05n

.meas tran vdout1_14ck340 FIND v(dout1_14) AT=350.05n

.meas tran vdout1_15ck340 FIND v(dout1_15) AT=350.05n

.meas tran vdout1_16ck340 FIND v(dout1_16) AT=350.05n

.meas tran vdout1_17ck340 FIND v(dout1_17) AT=350.05n

.meas tran vdout1_18ck340 FIND v(dout1_18) AT=350.05n

.meas tran vdout1_19ck340 FIND v(dout1_19) AT=350.05n

.meas tran vdout1_0ck350 FIND v(dout1_0) AT=360.05n

.meas tran vdout1_1ck350 FIND v(dout1_1) AT=360.05n

.meas tran vdout1_2ck350 FIND v(dout1_2) AT=360.05n

.meas tran vdout1_3ck350 FIND v(dout1_3) AT=360.05n

.meas tran vdout1_4ck350 FIND v(dout1_4) AT=360.05n

.meas tran vdout1_5ck350 FIND v(dout1_5) AT=360.05n

.meas tran vdout1_6ck350 FIND v(dout1_6) AT=360.05n

.meas tran vdout1_7ck350 FIND v(dout1_7) AT=360.05n

.meas tran vdout1_8ck350 FIND v(dout1_8) AT=360.05n

.meas tran vdout1_9ck350 FIND v(dout1_9) AT=360.05n

.meas tran vdout1_10ck350 FIND v(dout1_10) AT=360.05n

.meas tran vdout1_11ck350 FIND v(dout1_11) AT=360.05n

.meas tran vdout1_12ck350 FIND v(dout1_12) AT=360.05n

.meas tran vdout1_13ck350 FIND v(dout1_13) AT=360.05n

.meas tran vdout1_14ck350 FIND v(dout1_14) AT=360.05n

.meas tran vdout1_15ck350 FIND v(dout1_15) AT=360.05n

.meas tran vdout1_16ck350 FIND v(dout1_16) AT=360.05n

.meas tran vdout1_17ck350 FIND v(dout1_17) AT=360.05n

.meas tran vdout1_18ck350 FIND v(dout1_18) AT=360.05n

.meas tran vdout1_19ck350 FIND v(dout1_19) AT=360.05n

.meas tran vdout1_0ck380 FIND v(dout1_0) AT=390.05n

.meas tran vdout1_1ck380 FIND v(dout1_1) AT=390.05n

.meas tran vdout1_2ck380 FIND v(dout1_2) AT=390.05n

.meas tran vdout1_3ck380 FIND v(dout1_3) AT=390.05n

.meas tran vdout1_4ck380 FIND v(dout1_4) AT=390.05n

.meas tran vdout1_5ck380 FIND v(dout1_5) AT=390.05n

.meas tran vdout1_6ck380 FIND v(dout1_6) AT=390.05n

.meas tran vdout1_7ck380 FIND v(dout1_7) AT=390.05n

.meas tran vdout1_8ck380 FIND v(dout1_8) AT=390.05n

.meas tran vdout1_9ck380 FIND v(dout1_9) AT=390.05n

.meas tran vdout1_10ck380 FIND v(dout1_10) AT=390.05n

.meas tran vdout1_11ck380 FIND v(dout1_11) AT=390.05n

.meas tran vdout1_12ck380 FIND v(dout1_12) AT=390.05n

.meas tran vdout1_13ck380 FIND v(dout1_13) AT=390.05n

.meas tran vdout1_14ck380 FIND v(dout1_14) AT=390.05n

.meas tran vdout1_15ck380 FIND v(dout1_15) AT=390.05n

.meas tran vdout1_16ck380 FIND v(dout1_16) AT=390.05n

.meas tran vdout1_17ck380 FIND v(dout1_17) AT=390.05n

.meas tran vdout1_18ck380 FIND v(dout1_18) AT=390.05n

.meas tran vdout1_19ck380 FIND v(dout1_19) AT=390.05n

.meas tran vdout1_0ck430 FIND v(dout1_0) AT=440.05n

.meas tran vdout1_1ck430 FIND v(dout1_1) AT=440.05n

.meas tran vdout1_2ck430 FIND v(dout1_2) AT=440.05n

.meas tran vdout1_3ck430 FIND v(dout1_3) AT=440.05n

.meas tran vdout1_4ck430 FIND v(dout1_4) AT=440.05n

.meas tran vdout1_5ck430 FIND v(dout1_5) AT=440.05n

.meas tran vdout1_6ck430 FIND v(dout1_6) AT=440.05n

.meas tran vdout1_7ck430 FIND v(dout1_7) AT=440.05n

.meas tran vdout1_8ck430 FIND v(dout1_8) AT=440.05n

.meas tran vdout1_9ck430 FIND v(dout1_9) AT=440.05n

.meas tran vdout1_10ck430 FIND v(dout1_10) AT=440.05n

.meas tran vdout1_11ck430 FIND v(dout1_11) AT=440.05n

.meas tran vdout1_12ck430 FIND v(dout1_12) AT=440.05n

.meas tran vdout1_13ck430 FIND v(dout1_13) AT=440.05n

.meas tran vdout1_14ck430 FIND v(dout1_14) AT=440.05n

.meas tran vdout1_15ck430 FIND v(dout1_15) AT=440.05n

.meas tran vdout1_16ck430 FIND v(dout1_16) AT=440.05n

.meas tran vdout1_17ck430 FIND v(dout1_17) AT=440.05n

.meas tran vdout1_18ck430 FIND v(dout1_18) AT=440.05n

.meas tran vdout1_19ck430 FIND v(dout1_19) AT=440.05n

.meas tran vdout1_0ck480 FIND v(dout1_0) AT=490.05n

.meas tran vdout1_1ck480 FIND v(dout1_1) AT=490.05n

.meas tran vdout1_2ck480 FIND v(dout1_2) AT=490.05n

.meas tran vdout1_3ck480 FIND v(dout1_3) AT=490.05n

.meas tran vdout1_4ck480 FIND v(dout1_4) AT=490.05n

.meas tran vdout1_5ck480 FIND v(dout1_5) AT=490.05n

.meas tran vdout1_6ck480 FIND v(dout1_6) AT=490.05n

.meas tran vdout1_7ck480 FIND v(dout1_7) AT=490.05n

.meas tran vdout1_8ck480 FIND v(dout1_8) AT=490.05n

.meas tran vdout1_9ck480 FIND v(dout1_9) AT=490.05n

.meas tran vdout1_10ck480 FIND v(dout1_10) AT=490.05n

.meas tran vdout1_11ck480 FIND v(dout1_11) AT=490.05n

.meas tran vdout1_12ck480 FIND v(dout1_12) AT=490.05n

.meas tran vdout1_13ck480 FIND v(dout1_13) AT=490.05n

.meas tran vdout1_14ck480 FIND v(dout1_14) AT=490.05n

.meas tran vdout1_15ck480 FIND v(dout1_15) AT=490.05n

.meas tran vdout1_16ck480 FIND v(dout1_16) AT=490.05n

.meas tran vdout1_17ck480 FIND v(dout1_17) AT=490.05n

.meas tran vdout1_18ck480 FIND v(dout1_18) AT=490.05n

.meas tran vdout1_19ck480 FIND v(dout1_19) AT=490.05n

.meas tran vdout1_0ck510 FIND v(dout1_0) AT=520.05n

.meas tran vdout1_1ck510 FIND v(dout1_1) AT=520.05n

.meas tran vdout1_2ck510 FIND v(dout1_2) AT=520.05n

.meas tran vdout1_3ck510 FIND v(dout1_3) AT=520.05n

.meas tran vdout1_4ck510 FIND v(dout1_4) AT=520.05n

.meas tran vdout1_5ck510 FIND v(dout1_5) AT=520.05n

.meas tran vdout1_6ck510 FIND v(dout1_6) AT=520.05n

.meas tran vdout1_7ck510 FIND v(dout1_7) AT=520.05n

.meas tran vdout1_8ck510 FIND v(dout1_8) AT=520.05n

.meas tran vdout1_9ck510 FIND v(dout1_9) AT=520.05n

.meas tran vdout1_10ck510 FIND v(dout1_10) AT=520.05n

.meas tran vdout1_11ck510 FIND v(dout1_11) AT=520.05n

.meas tran vdout1_12ck510 FIND v(dout1_12) AT=520.05n

.meas tran vdout1_13ck510 FIND v(dout1_13) AT=520.05n

.meas tran vdout1_14ck510 FIND v(dout1_14) AT=520.05n

.meas tran vdout1_15ck510 FIND v(dout1_15) AT=520.05n

.meas tran vdout1_16ck510 FIND v(dout1_16) AT=520.05n

.meas tran vdout1_17ck510 FIND v(dout1_17) AT=520.05n

.meas tran vdout1_18ck510 FIND v(dout1_18) AT=520.05n

.meas tran vdout1_19ck510 FIND v(dout1_19) AT=520.05n

.meas tran vdout1_0ck540 FIND v(dout1_0) AT=550.05n

.meas tran vdout1_1ck540 FIND v(dout1_1) AT=550.05n

.meas tran vdout1_2ck540 FIND v(dout1_2) AT=550.05n

.meas tran vdout1_3ck540 FIND v(dout1_3) AT=550.05n

.meas tran vdout1_4ck540 FIND v(dout1_4) AT=550.05n

.meas tran vdout1_5ck540 FIND v(dout1_5) AT=550.05n

.meas tran vdout1_6ck540 FIND v(dout1_6) AT=550.05n

.meas tran vdout1_7ck540 FIND v(dout1_7) AT=550.05n

.meas tran vdout1_8ck540 FIND v(dout1_8) AT=550.05n

.meas tran vdout1_9ck540 FIND v(dout1_9) AT=550.05n

.meas tran vdout1_10ck540 FIND v(dout1_10) AT=550.05n

.meas tran vdout1_11ck540 FIND v(dout1_11) AT=550.05n

.meas tran vdout1_12ck540 FIND v(dout1_12) AT=550.05n

.meas tran vdout1_13ck540 FIND v(dout1_13) AT=550.05n

.meas tran vdout1_14ck540 FIND v(dout1_14) AT=550.05n

.meas tran vdout1_15ck540 FIND v(dout1_15) AT=550.05n

.meas tran vdout1_16ck540 FIND v(dout1_16) AT=550.05n

.meas tran vdout1_17ck540 FIND v(dout1_17) AT=550.05n

.meas tran vdout1_18ck540 FIND v(dout1_18) AT=550.05n

.meas tran vdout1_19ck540 FIND v(dout1_19) AT=550.05n

.meas tran vdout1_0ck550 FIND v(dout1_0) AT=560.05n

.meas tran vdout1_1ck550 FIND v(dout1_1) AT=560.05n

.meas tran vdout1_2ck550 FIND v(dout1_2) AT=560.05n

.meas tran vdout1_3ck550 FIND v(dout1_3) AT=560.05n

.meas tran vdout1_4ck550 FIND v(dout1_4) AT=560.05n

.meas tran vdout1_5ck550 FIND v(dout1_5) AT=560.05n

.meas tran vdout1_6ck550 FIND v(dout1_6) AT=560.05n

.meas tran vdout1_7ck550 FIND v(dout1_7) AT=560.05n

.meas tran vdout1_8ck550 FIND v(dout1_8) AT=560.05n

.meas tran vdout1_9ck550 FIND v(dout1_9) AT=560.05n

.meas tran vdout1_10ck550 FIND v(dout1_10) AT=560.05n

.meas tran vdout1_11ck550 FIND v(dout1_11) AT=560.05n

.meas tran vdout1_12ck550 FIND v(dout1_12) AT=560.05n

.meas tran vdout1_13ck550 FIND v(dout1_13) AT=560.05n

.meas tran vdout1_14ck550 FIND v(dout1_14) AT=560.05n

.meas tran vdout1_15ck550 FIND v(dout1_15) AT=560.05n

.meas tran vdout1_16ck550 FIND v(dout1_16) AT=560.05n

.meas tran vdout1_17ck550 FIND v(dout1_17) AT=560.05n

.meas tran vdout1_18ck550 FIND v(dout1_18) AT=560.05n

.meas tran vdout1_19ck550 FIND v(dout1_19) AT=560.05n

.meas tran vdout1_0ck570 FIND v(dout1_0) AT=580.05n

.meas tran vdout1_1ck570 FIND v(dout1_1) AT=580.05n

.meas tran vdout1_2ck570 FIND v(dout1_2) AT=580.05n

.meas tran vdout1_3ck570 FIND v(dout1_3) AT=580.05n

.meas tran vdout1_4ck570 FIND v(dout1_4) AT=580.05n

.meas tran vdout1_5ck570 FIND v(dout1_5) AT=580.05n

.meas tran vdout1_6ck570 FIND v(dout1_6) AT=580.05n

.meas tran vdout1_7ck570 FIND v(dout1_7) AT=580.05n

.meas tran vdout1_8ck570 FIND v(dout1_8) AT=580.05n

.meas tran vdout1_9ck570 FIND v(dout1_9) AT=580.05n

.meas tran vdout1_10ck570 FIND v(dout1_10) AT=580.05n

.meas tran vdout1_11ck570 FIND v(dout1_11) AT=580.05n

.meas tran vdout1_12ck570 FIND v(dout1_12) AT=580.05n

.meas tran vdout1_13ck570 FIND v(dout1_13) AT=580.05n

.meas tran vdout1_14ck570 FIND v(dout1_14) AT=580.05n

.meas tran vdout1_15ck570 FIND v(dout1_15) AT=580.05n

.meas tran vdout1_16ck570 FIND v(dout1_16) AT=580.05n

.meas tran vdout1_17ck570 FIND v(dout1_17) AT=580.05n

.meas tran vdout1_18ck570 FIND v(dout1_18) AT=580.05n

.meas tran vdout1_19ck570 FIND v(dout1_19) AT=580.05n

.meas tran vdout1_0ck580 FIND v(dout1_0) AT=590.05n

.meas tran vdout1_1ck580 FIND v(dout1_1) AT=590.05n

.meas tran vdout1_2ck580 FIND v(dout1_2) AT=590.05n

.meas tran vdout1_3ck580 FIND v(dout1_3) AT=590.05n

.meas tran vdout1_4ck580 FIND v(dout1_4) AT=590.05n

.meas tran vdout1_5ck580 FIND v(dout1_5) AT=590.05n

.meas tran vdout1_6ck580 FIND v(dout1_6) AT=590.05n

.meas tran vdout1_7ck580 FIND v(dout1_7) AT=590.05n

.meas tran vdout1_8ck580 FIND v(dout1_8) AT=590.05n

.meas tran vdout1_9ck580 FIND v(dout1_9) AT=590.05n

.meas tran vdout1_10ck580 FIND v(dout1_10) AT=590.05n

.meas tran vdout1_11ck580 FIND v(dout1_11) AT=590.05n

.meas tran vdout1_12ck580 FIND v(dout1_12) AT=590.05n

.meas tran vdout1_13ck580 FIND v(dout1_13) AT=590.05n

.meas tran vdout1_14ck580 FIND v(dout1_14) AT=590.05n

.meas tran vdout1_15ck580 FIND v(dout1_15) AT=590.05n

.meas tran vdout1_16ck580 FIND v(dout1_16) AT=590.05n

.meas tran vdout1_17ck580 FIND v(dout1_17) AT=590.05n

.meas tran vdout1_18ck580 FIND v(dout1_18) AT=590.05n

.meas tran vdout1_19ck580 FIND v(dout1_19) AT=590.05n

.meas tran vdout1_0ck630 FIND v(dout1_0) AT=640.05n

.meas tran vdout1_1ck630 FIND v(dout1_1) AT=640.05n

.meas tran vdout1_2ck630 FIND v(dout1_2) AT=640.05n

.meas tran vdout1_3ck630 FIND v(dout1_3) AT=640.05n

.meas tran vdout1_4ck630 FIND v(dout1_4) AT=640.05n

.meas tran vdout1_5ck630 FIND v(dout1_5) AT=640.05n

.meas tran vdout1_6ck630 FIND v(dout1_6) AT=640.05n

.meas tran vdout1_7ck630 FIND v(dout1_7) AT=640.05n

.meas tran vdout1_8ck630 FIND v(dout1_8) AT=640.05n

.meas tran vdout1_9ck630 FIND v(dout1_9) AT=640.05n

.meas tran vdout1_10ck630 FIND v(dout1_10) AT=640.05n

.meas tran vdout1_11ck630 FIND v(dout1_11) AT=640.05n

.meas tran vdout1_12ck630 FIND v(dout1_12) AT=640.05n

.meas tran vdout1_13ck630 FIND v(dout1_13) AT=640.05n

.meas tran vdout1_14ck630 FIND v(dout1_14) AT=640.05n

.meas tran vdout1_15ck630 FIND v(dout1_15) AT=640.05n

.meas tran vdout1_16ck630 FIND v(dout1_16) AT=640.05n

.meas tran vdout1_17ck630 FIND v(dout1_17) AT=640.05n

.meas tran vdout1_18ck630 FIND v(dout1_18) AT=640.05n

.meas tran vdout1_19ck630 FIND v(dout1_19) AT=640.05n

.meas tran vdout1_0ck680 FIND v(dout1_0) AT=690.05n

.meas tran vdout1_1ck680 FIND v(dout1_1) AT=690.05n

.meas tran vdout1_2ck680 FIND v(dout1_2) AT=690.05n

.meas tran vdout1_3ck680 FIND v(dout1_3) AT=690.05n

.meas tran vdout1_4ck680 FIND v(dout1_4) AT=690.05n

.meas tran vdout1_5ck680 FIND v(dout1_5) AT=690.05n

.meas tran vdout1_6ck680 FIND v(dout1_6) AT=690.05n

.meas tran vdout1_7ck680 FIND v(dout1_7) AT=690.05n

.meas tran vdout1_8ck680 FIND v(dout1_8) AT=690.05n

.meas tran vdout1_9ck680 FIND v(dout1_9) AT=690.05n

.meas tran vdout1_10ck680 FIND v(dout1_10) AT=690.05n

.meas tran vdout1_11ck680 FIND v(dout1_11) AT=690.05n

.meas tran vdout1_12ck680 FIND v(dout1_12) AT=690.05n

.meas tran vdout1_13ck680 FIND v(dout1_13) AT=690.05n

.meas tran vdout1_14ck680 FIND v(dout1_14) AT=690.05n

.meas tran vdout1_15ck680 FIND v(dout1_15) AT=690.05n

.meas tran vdout1_16ck680 FIND v(dout1_16) AT=690.05n

.meas tran vdout1_17ck680 FIND v(dout1_17) AT=690.05n

.meas tran vdout1_18ck680 FIND v(dout1_18) AT=690.05n

.meas tran vdout1_19ck680 FIND v(dout1_19) AT=690.05n

.meas tran vdout1_0ck700 FIND v(dout1_0) AT=710.05n

.meas tran vdout1_1ck700 FIND v(dout1_1) AT=710.05n

.meas tran vdout1_2ck700 FIND v(dout1_2) AT=710.05n

.meas tran vdout1_3ck700 FIND v(dout1_3) AT=710.05n

.meas tran vdout1_4ck700 FIND v(dout1_4) AT=710.05n

.meas tran vdout1_5ck700 FIND v(dout1_5) AT=710.05n

.meas tran vdout1_6ck700 FIND v(dout1_6) AT=710.05n

.meas tran vdout1_7ck700 FIND v(dout1_7) AT=710.05n

.meas tran vdout1_8ck700 FIND v(dout1_8) AT=710.05n

.meas tran vdout1_9ck700 FIND v(dout1_9) AT=710.05n

.meas tran vdout1_10ck700 FIND v(dout1_10) AT=710.05n

.meas tran vdout1_11ck700 FIND v(dout1_11) AT=710.05n

.meas tran vdout1_12ck700 FIND v(dout1_12) AT=710.05n

.meas tran vdout1_13ck700 FIND v(dout1_13) AT=710.05n

.meas tran vdout1_14ck700 FIND v(dout1_14) AT=710.05n

.meas tran vdout1_15ck700 FIND v(dout1_15) AT=710.05n

.meas tran vdout1_16ck700 FIND v(dout1_16) AT=710.05n

.meas tran vdout1_17ck700 FIND v(dout1_17) AT=710.05n

.meas tran vdout1_18ck700 FIND v(dout1_18) AT=710.05n

.meas tran vdout1_19ck700 FIND v(dout1_19) AT=710.05n

.meas tran vdout1_0ck750 FIND v(dout1_0) AT=760.05n

.meas tran vdout1_1ck750 FIND v(dout1_1) AT=760.05n

.meas tran vdout1_2ck750 FIND v(dout1_2) AT=760.05n

.meas tran vdout1_3ck750 FIND v(dout1_3) AT=760.05n

.meas tran vdout1_4ck750 FIND v(dout1_4) AT=760.05n

.meas tran vdout1_5ck750 FIND v(dout1_5) AT=760.05n

.meas tran vdout1_6ck750 FIND v(dout1_6) AT=760.05n

.meas tran vdout1_7ck750 FIND v(dout1_7) AT=760.05n

.meas tran vdout1_8ck750 FIND v(dout1_8) AT=760.05n

.meas tran vdout1_9ck750 FIND v(dout1_9) AT=760.05n

.meas tran vdout1_10ck750 FIND v(dout1_10) AT=760.05n

.meas tran vdout1_11ck750 FIND v(dout1_11) AT=760.05n

.meas tran vdout1_12ck750 FIND v(dout1_12) AT=760.05n

.meas tran vdout1_13ck750 FIND v(dout1_13) AT=760.05n

.meas tran vdout1_14ck750 FIND v(dout1_14) AT=760.05n

.meas tran vdout1_15ck750 FIND v(dout1_15) AT=760.05n

.meas tran vdout1_16ck750 FIND v(dout1_16) AT=760.05n

.meas tran vdout1_17ck750 FIND v(dout1_17) AT=760.05n

.meas tran vdout1_18ck750 FIND v(dout1_18) AT=760.05n

.meas tran vdout1_19ck750 FIND v(dout1_19) AT=760.05n

.meas tran vdout1_0ck770 FIND v(dout1_0) AT=780.05n

.meas tran vdout1_1ck770 FIND v(dout1_1) AT=780.05n

.meas tran vdout1_2ck770 FIND v(dout1_2) AT=780.05n

.meas tran vdout1_3ck770 FIND v(dout1_3) AT=780.05n

.meas tran vdout1_4ck770 FIND v(dout1_4) AT=780.05n

.meas tran vdout1_5ck770 FIND v(dout1_5) AT=780.05n

.meas tran vdout1_6ck770 FIND v(dout1_6) AT=780.05n

.meas tran vdout1_7ck770 FIND v(dout1_7) AT=780.05n

.meas tran vdout1_8ck770 FIND v(dout1_8) AT=780.05n

.meas tran vdout1_9ck770 FIND v(dout1_9) AT=780.05n

.meas tran vdout1_10ck770 FIND v(dout1_10) AT=780.05n

.meas tran vdout1_11ck770 FIND v(dout1_11) AT=780.05n

.meas tran vdout1_12ck770 FIND v(dout1_12) AT=780.05n

.meas tran vdout1_13ck770 FIND v(dout1_13) AT=780.05n

.meas tran vdout1_14ck770 FIND v(dout1_14) AT=780.05n

.meas tran vdout1_15ck770 FIND v(dout1_15) AT=780.05n

.meas tran vdout1_16ck770 FIND v(dout1_16) AT=780.05n

.meas tran vdout1_17ck770 FIND v(dout1_17) AT=780.05n

.meas tran vdout1_18ck770 FIND v(dout1_18) AT=780.05n

.meas tran vdout1_19ck770 FIND v(dout1_19) AT=780.05n

.meas tran vdout1_0ck790 FIND v(dout1_0) AT=800.05n

.meas tran vdout1_1ck790 FIND v(dout1_1) AT=800.05n

.meas tran vdout1_2ck790 FIND v(dout1_2) AT=800.05n

.meas tran vdout1_3ck790 FIND v(dout1_3) AT=800.05n

.meas tran vdout1_4ck790 FIND v(dout1_4) AT=800.05n

.meas tran vdout1_5ck790 FIND v(dout1_5) AT=800.05n

.meas tran vdout1_6ck790 FIND v(dout1_6) AT=800.05n

.meas tran vdout1_7ck790 FIND v(dout1_7) AT=800.05n

.meas tran vdout1_8ck790 FIND v(dout1_8) AT=800.05n

.meas tran vdout1_9ck790 FIND v(dout1_9) AT=800.05n

.meas tran vdout1_10ck790 FIND v(dout1_10) AT=800.05n

.meas tran vdout1_11ck790 FIND v(dout1_11) AT=800.05n

.meas tran vdout1_12ck790 FIND v(dout1_12) AT=800.05n

.meas tran vdout1_13ck790 FIND v(dout1_13) AT=800.05n

.meas tran vdout1_14ck790 FIND v(dout1_14) AT=800.05n

.meas tran vdout1_15ck790 FIND v(dout1_15) AT=800.05n

.meas tran vdout1_16ck790 FIND v(dout1_16) AT=800.05n

.meas tran vdout1_17ck790 FIND v(dout1_17) AT=800.05n

.meas tran vdout1_18ck790 FIND v(dout1_18) AT=800.05n

.meas tran vdout1_19ck790 FIND v(dout1_19) AT=800.05n

.meas tran vdout1_0ck800 FIND v(dout1_0) AT=810.05n

.meas tran vdout1_1ck800 FIND v(dout1_1) AT=810.05n

.meas tran vdout1_2ck800 FIND v(dout1_2) AT=810.05n

.meas tran vdout1_3ck800 FIND v(dout1_3) AT=810.05n

.meas tran vdout1_4ck800 FIND v(dout1_4) AT=810.05n

.meas tran vdout1_5ck800 FIND v(dout1_5) AT=810.05n

.meas tran vdout1_6ck800 FIND v(dout1_6) AT=810.05n

.meas tran vdout1_7ck800 FIND v(dout1_7) AT=810.05n

.meas tran vdout1_8ck800 FIND v(dout1_8) AT=810.05n

.meas tran vdout1_9ck800 FIND v(dout1_9) AT=810.05n

.meas tran vdout1_10ck800 FIND v(dout1_10) AT=810.05n

.meas tran vdout1_11ck800 FIND v(dout1_11) AT=810.05n

.meas tran vdout1_12ck800 FIND v(dout1_12) AT=810.05n

.meas tran vdout1_13ck800 FIND v(dout1_13) AT=810.05n

.meas tran vdout1_14ck800 FIND v(dout1_14) AT=810.05n

.meas tran vdout1_15ck800 FIND v(dout1_15) AT=810.05n

.meas tran vdout1_16ck800 FIND v(dout1_16) AT=810.05n

.meas tran vdout1_17ck800 FIND v(dout1_17) AT=810.05n

.meas tran vdout1_18ck800 FIND v(dout1_18) AT=810.05n

.meas tran vdout1_19ck800 FIND v(dout1_19) AT=810.05n

.meas tran vdout1_0ck820 FIND v(dout1_0) AT=830.05n

.meas tran vdout1_1ck820 FIND v(dout1_1) AT=830.05n

.meas tran vdout1_2ck820 FIND v(dout1_2) AT=830.05n

.meas tran vdout1_3ck820 FIND v(dout1_3) AT=830.05n

.meas tran vdout1_4ck820 FIND v(dout1_4) AT=830.05n

.meas tran vdout1_5ck820 FIND v(dout1_5) AT=830.05n

.meas tran vdout1_6ck820 FIND v(dout1_6) AT=830.05n

.meas tran vdout1_7ck820 FIND v(dout1_7) AT=830.05n

.meas tran vdout1_8ck820 FIND v(dout1_8) AT=830.05n

.meas tran vdout1_9ck820 FIND v(dout1_9) AT=830.05n

.meas tran vdout1_10ck820 FIND v(dout1_10) AT=830.05n

.meas tran vdout1_11ck820 FIND v(dout1_11) AT=830.05n

.meas tran vdout1_12ck820 FIND v(dout1_12) AT=830.05n

.meas tran vdout1_13ck820 FIND v(dout1_13) AT=830.05n

.meas tran vdout1_14ck820 FIND v(dout1_14) AT=830.05n

.meas tran vdout1_15ck820 FIND v(dout1_15) AT=830.05n

.meas tran vdout1_16ck820 FIND v(dout1_16) AT=830.05n

.meas tran vdout1_17ck820 FIND v(dout1_17) AT=830.05n

.meas tran vdout1_18ck820 FIND v(dout1_18) AT=830.05n

.meas tran vdout1_19ck820 FIND v(dout1_19) AT=830.05n

.meas tran vdout1_0ck860 FIND v(dout1_0) AT=870.05n

.meas tran vdout1_1ck860 FIND v(dout1_1) AT=870.05n

.meas tran vdout1_2ck860 FIND v(dout1_2) AT=870.05n

.meas tran vdout1_3ck860 FIND v(dout1_3) AT=870.05n

.meas tran vdout1_4ck860 FIND v(dout1_4) AT=870.05n

.meas tran vdout1_5ck860 FIND v(dout1_5) AT=870.05n

.meas tran vdout1_6ck860 FIND v(dout1_6) AT=870.05n

.meas tran vdout1_7ck860 FIND v(dout1_7) AT=870.05n

.meas tran vdout1_8ck860 FIND v(dout1_8) AT=870.05n

.meas tran vdout1_9ck860 FIND v(dout1_9) AT=870.05n

.meas tran vdout1_10ck860 FIND v(dout1_10) AT=870.05n

.meas tran vdout1_11ck860 FIND v(dout1_11) AT=870.05n

.meas tran vdout1_12ck860 FIND v(dout1_12) AT=870.05n

.meas tran vdout1_13ck860 FIND v(dout1_13) AT=870.05n

.meas tran vdout1_14ck860 FIND v(dout1_14) AT=870.05n

.meas tran vdout1_15ck860 FIND v(dout1_15) AT=870.05n

.meas tran vdout1_16ck860 FIND v(dout1_16) AT=870.05n

.meas tran vdout1_17ck860 FIND v(dout1_17) AT=870.05n

.meas tran vdout1_18ck860 FIND v(dout1_18) AT=870.05n

.meas tran vdout1_19ck860 FIND v(dout1_19) AT=870.05n

.meas tran vdout1_0ck890 FIND v(dout1_0) AT=900.05n

.meas tran vdout1_1ck890 FIND v(dout1_1) AT=900.05n

.meas tran vdout1_2ck890 FIND v(dout1_2) AT=900.05n

.meas tran vdout1_3ck890 FIND v(dout1_3) AT=900.05n

.meas tran vdout1_4ck890 FIND v(dout1_4) AT=900.05n

.meas tran vdout1_5ck890 FIND v(dout1_5) AT=900.05n

.meas tran vdout1_6ck890 FIND v(dout1_6) AT=900.05n

.meas tran vdout1_7ck890 FIND v(dout1_7) AT=900.05n

.meas tran vdout1_8ck890 FIND v(dout1_8) AT=900.05n

.meas tran vdout1_9ck890 FIND v(dout1_9) AT=900.05n

.meas tran vdout1_10ck890 FIND v(dout1_10) AT=900.05n

.meas tran vdout1_11ck890 FIND v(dout1_11) AT=900.05n

.meas tran vdout1_12ck890 FIND v(dout1_12) AT=900.05n

.meas tran vdout1_13ck890 FIND v(dout1_13) AT=900.05n

.meas tran vdout1_14ck890 FIND v(dout1_14) AT=900.05n

.meas tran vdout1_15ck890 FIND v(dout1_15) AT=900.05n

.meas tran vdout1_16ck890 FIND v(dout1_16) AT=900.05n

.meas tran vdout1_17ck890 FIND v(dout1_17) AT=900.05n

.meas tran vdout1_18ck890 FIND v(dout1_18) AT=900.05n

.meas tran vdout1_19ck890 FIND v(dout1_19) AT=900.05n

.meas tran vdout1_0ck910 FIND v(dout1_0) AT=920.05n

.meas tran vdout1_1ck910 FIND v(dout1_1) AT=920.05n

.meas tran vdout1_2ck910 FIND v(dout1_2) AT=920.05n

.meas tran vdout1_3ck910 FIND v(dout1_3) AT=920.05n

.meas tran vdout1_4ck910 FIND v(dout1_4) AT=920.05n

.meas tran vdout1_5ck910 FIND v(dout1_5) AT=920.05n

.meas tran vdout1_6ck910 FIND v(dout1_6) AT=920.05n

.meas tran vdout1_7ck910 FIND v(dout1_7) AT=920.05n

.meas tran vdout1_8ck910 FIND v(dout1_8) AT=920.05n

.meas tran vdout1_9ck910 FIND v(dout1_9) AT=920.05n

.meas tran vdout1_10ck910 FIND v(dout1_10) AT=920.05n

.meas tran vdout1_11ck910 FIND v(dout1_11) AT=920.05n

.meas tran vdout1_12ck910 FIND v(dout1_12) AT=920.05n

.meas tran vdout1_13ck910 FIND v(dout1_13) AT=920.05n

.meas tran vdout1_14ck910 FIND v(dout1_14) AT=920.05n

.meas tran vdout1_15ck910 FIND v(dout1_15) AT=920.05n

.meas tran vdout1_16ck910 FIND v(dout1_16) AT=920.05n

.meas tran vdout1_17ck910 FIND v(dout1_17) AT=920.05n

.meas tran vdout1_18ck910 FIND v(dout1_18) AT=920.05n

.meas tran vdout1_19ck910 FIND v(dout1_19) AT=920.05n

.meas tran vdout1_0ck940 FIND v(dout1_0) AT=950.05n

.meas tran vdout1_1ck940 FIND v(dout1_1) AT=950.05n

.meas tran vdout1_2ck940 FIND v(dout1_2) AT=950.05n

.meas tran vdout1_3ck940 FIND v(dout1_3) AT=950.05n

.meas tran vdout1_4ck940 FIND v(dout1_4) AT=950.05n

.meas tran vdout1_5ck940 FIND v(dout1_5) AT=950.05n

.meas tran vdout1_6ck940 FIND v(dout1_6) AT=950.05n

.meas tran vdout1_7ck940 FIND v(dout1_7) AT=950.05n

.meas tran vdout1_8ck940 FIND v(dout1_8) AT=950.05n

.meas tran vdout1_9ck940 FIND v(dout1_9) AT=950.05n

.meas tran vdout1_10ck940 FIND v(dout1_10) AT=950.05n

.meas tran vdout1_11ck940 FIND v(dout1_11) AT=950.05n

.meas tran vdout1_12ck940 FIND v(dout1_12) AT=950.05n

.meas tran vdout1_13ck940 FIND v(dout1_13) AT=950.05n

.meas tran vdout1_14ck940 FIND v(dout1_14) AT=950.05n

.meas tran vdout1_15ck940 FIND v(dout1_15) AT=950.05n

.meas tran vdout1_16ck940 FIND v(dout1_16) AT=950.05n

.meas tran vdout1_17ck940 FIND v(dout1_17) AT=950.05n

.meas tran vdout1_18ck940 FIND v(dout1_18) AT=950.05n

.meas tran vdout1_19ck940 FIND v(dout1_19) AT=950.05n

.meas tran vdout1_0ck950 FIND v(dout1_0) AT=960.05n

.meas tran vdout1_1ck950 FIND v(dout1_1) AT=960.05n

.meas tran vdout1_2ck950 FIND v(dout1_2) AT=960.05n

.meas tran vdout1_3ck950 FIND v(dout1_3) AT=960.05n

.meas tran vdout1_4ck950 FIND v(dout1_4) AT=960.05n

.meas tran vdout1_5ck950 FIND v(dout1_5) AT=960.05n

.meas tran vdout1_6ck950 FIND v(dout1_6) AT=960.05n

.meas tran vdout1_7ck950 FIND v(dout1_7) AT=960.05n

.meas tran vdout1_8ck950 FIND v(dout1_8) AT=960.05n

.meas tran vdout1_9ck950 FIND v(dout1_9) AT=960.05n

.meas tran vdout1_10ck950 FIND v(dout1_10) AT=960.05n

.meas tran vdout1_11ck950 FIND v(dout1_11) AT=960.05n

.meas tran vdout1_12ck950 FIND v(dout1_12) AT=960.05n

.meas tran vdout1_13ck950 FIND v(dout1_13) AT=960.05n

.meas tran vdout1_14ck950 FIND v(dout1_14) AT=960.05n

.meas tran vdout1_15ck950 FIND v(dout1_15) AT=960.05n

.meas tran vdout1_16ck950 FIND v(dout1_16) AT=960.05n

.meas tran vdout1_17ck950 FIND v(dout1_17) AT=960.05n

.meas tran vdout1_18ck950 FIND v(dout1_18) AT=960.05n

.meas tran vdout1_19ck950 FIND v(dout1_19) AT=960.05n

.meas tran vdout1_0ck960 FIND v(dout1_0) AT=970.05n

.meas tran vdout1_1ck960 FIND v(dout1_1) AT=970.05n

.meas tran vdout1_2ck960 FIND v(dout1_2) AT=970.05n

.meas tran vdout1_3ck960 FIND v(dout1_3) AT=970.05n

.meas tran vdout1_4ck960 FIND v(dout1_4) AT=970.05n

.meas tran vdout1_5ck960 FIND v(dout1_5) AT=970.05n

.meas tran vdout1_6ck960 FIND v(dout1_6) AT=970.05n

.meas tran vdout1_7ck960 FIND v(dout1_7) AT=970.05n

.meas tran vdout1_8ck960 FIND v(dout1_8) AT=970.05n

.meas tran vdout1_9ck960 FIND v(dout1_9) AT=970.05n

.meas tran vdout1_10ck960 FIND v(dout1_10) AT=970.05n

.meas tran vdout1_11ck960 FIND v(dout1_11) AT=970.05n

.meas tran vdout1_12ck960 FIND v(dout1_12) AT=970.05n

.meas tran vdout1_13ck960 FIND v(dout1_13) AT=970.05n

.meas tran vdout1_14ck960 FIND v(dout1_14) AT=970.05n

.meas tran vdout1_15ck960 FIND v(dout1_15) AT=970.05n

.meas tran vdout1_16ck960 FIND v(dout1_16) AT=970.05n

.meas tran vdout1_17ck960 FIND v(dout1_17) AT=970.05n

.meas tran vdout1_18ck960 FIND v(dout1_18) AT=970.05n

.meas tran vdout1_19ck960 FIND v(dout1_19) AT=970.05n

.meas tran vdout1_0ck970 FIND v(dout1_0) AT=980.05n

.meas tran vdout1_1ck970 FIND v(dout1_1) AT=980.05n

.meas tran vdout1_2ck970 FIND v(dout1_2) AT=980.05n

.meas tran vdout1_3ck970 FIND v(dout1_3) AT=980.05n

.meas tran vdout1_4ck970 FIND v(dout1_4) AT=980.05n

.meas tran vdout1_5ck970 FIND v(dout1_5) AT=980.05n

.meas tran vdout1_6ck970 FIND v(dout1_6) AT=980.05n

.meas tran vdout1_7ck970 FIND v(dout1_7) AT=980.05n

.meas tran vdout1_8ck970 FIND v(dout1_8) AT=980.05n

.meas tran vdout1_9ck970 FIND v(dout1_9) AT=980.05n

.meas tran vdout1_10ck970 FIND v(dout1_10) AT=980.05n

.meas tran vdout1_11ck970 FIND v(dout1_11) AT=980.05n

.meas tran vdout1_12ck970 FIND v(dout1_12) AT=980.05n

.meas tran vdout1_13ck970 FIND v(dout1_13) AT=980.05n

.meas tran vdout1_14ck970 FIND v(dout1_14) AT=980.05n

.meas tran vdout1_15ck970 FIND v(dout1_15) AT=980.05n

.meas tran vdout1_16ck970 FIND v(dout1_16) AT=980.05n

.meas tran vdout1_17ck970 FIND v(dout1_17) AT=980.05n

.meas tran vdout1_18ck970 FIND v(dout1_18) AT=980.05n

.meas tran vdout1_19ck970 FIND v(dout1_19) AT=980.05n

.meas tran vdout1_0ck990 FIND v(dout1_0) AT=1000.05n

.meas tran vdout1_1ck990 FIND v(dout1_1) AT=1000.05n

.meas tran vdout1_2ck990 FIND v(dout1_2) AT=1000.05n

.meas tran vdout1_3ck990 FIND v(dout1_3) AT=1000.05n

.meas tran vdout1_4ck990 FIND v(dout1_4) AT=1000.05n

.meas tran vdout1_5ck990 FIND v(dout1_5) AT=1000.05n

.meas tran vdout1_6ck990 FIND v(dout1_6) AT=1000.05n

.meas tran vdout1_7ck990 FIND v(dout1_7) AT=1000.05n

.meas tran vdout1_8ck990 FIND v(dout1_8) AT=1000.05n

.meas tran vdout1_9ck990 FIND v(dout1_9) AT=1000.05n

.meas tran vdout1_10ck990 FIND v(dout1_10) AT=1000.05n

.meas tran vdout1_11ck990 FIND v(dout1_11) AT=1000.05n

.meas tran vdout1_12ck990 FIND v(dout1_12) AT=1000.05n

.meas tran vdout1_13ck990 FIND v(dout1_13) AT=1000.05n

.meas tran vdout1_14ck990 FIND v(dout1_14) AT=1000.05n

.meas tran vdout1_15ck990 FIND v(dout1_15) AT=1000.05n

.meas tran vdout1_16ck990 FIND v(dout1_16) AT=1000.05n

.meas tran vdout1_17ck990 FIND v(dout1_17) AT=1000.05n

.meas tran vdout1_18ck990 FIND v(dout1_18) AT=1000.05n

.meas tran vdout1_19ck990 FIND v(dout1_19) AT=1000.05n

.meas tran vdout1_0ck1040 FIND v(dout1_0) AT=1050.05n

.meas tran vdout1_1ck1040 FIND v(dout1_1) AT=1050.05n

.meas tran vdout1_2ck1040 FIND v(dout1_2) AT=1050.05n

.meas tran vdout1_3ck1040 FIND v(dout1_3) AT=1050.05n

.meas tran vdout1_4ck1040 FIND v(dout1_4) AT=1050.05n

.meas tran vdout1_5ck1040 FIND v(dout1_5) AT=1050.05n

.meas tran vdout1_6ck1040 FIND v(dout1_6) AT=1050.05n

.meas tran vdout1_7ck1040 FIND v(dout1_7) AT=1050.05n

.meas tran vdout1_8ck1040 FIND v(dout1_8) AT=1050.05n

.meas tran vdout1_9ck1040 FIND v(dout1_9) AT=1050.05n

.meas tran vdout1_10ck1040 FIND v(dout1_10) AT=1050.05n

.meas tran vdout1_11ck1040 FIND v(dout1_11) AT=1050.05n

.meas tran vdout1_12ck1040 FIND v(dout1_12) AT=1050.05n

.meas tran vdout1_13ck1040 FIND v(dout1_13) AT=1050.05n

.meas tran vdout1_14ck1040 FIND v(dout1_14) AT=1050.05n

.meas tran vdout1_15ck1040 FIND v(dout1_15) AT=1050.05n

.meas tran vdout1_16ck1040 FIND v(dout1_16) AT=1050.05n

.meas tran vdout1_17ck1040 FIND v(dout1_17) AT=1050.05n

.meas tran vdout1_18ck1040 FIND v(dout1_18) AT=1050.05n

.meas tran vdout1_19ck1040 FIND v(dout1_19) AT=1050.05n

.meas tran vdout1_0ck1080 FIND v(dout1_0) AT=1090.05n

.meas tran vdout1_1ck1080 FIND v(dout1_1) AT=1090.05n

.meas tran vdout1_2ck1080 FIND v(dout1_2) AT=1090.05n

.meas tran vdout1_3ck1080 FIND v(dout1_3) AT=1090.05n

.meas tran vdout1_4ck1080 FIND v(dout1_4) AT=1090.05n

.meas tran vdout1_5ck1080 FIND v(dout1_5) AT=1090.05n

.meas tran vdout1_6ck1080 FIND v(dout1_6) AT=1090.05n

.meas tran vdout1_7ck1080 FIND v(dout1_7) AT=1090.05n

.meas tran vdout1_8ck1080 FIND v(dout1_8) AT=1090.05n

.meas tran vdout1_9ck1080 FIND v(dout1_9) AT=1090.05n

.meas tran vdout1_10ck1080 FIND v(dout1_10) AT=1090.05n

.meas tran vdout1_11ck1080 FIND v(dout1_11) AT=1090.05n

.meas tran vdout1_12ck1080 FIND v(dout1_12) AT=1090.05n

.meas tran vdout1_13ck1080 FIND v(dout1_13) AT=1090.05n

.meas tran vdout1_14ck1080 FIND v(dout1_14) AT=1090.05n

.meas tran vdout1_15ck1080 FIND v(dout1_15) AT=1090.05n

.meas tran vdout1_16ck1080 FIND v(dout1_16) AT=1090.05n

.meas tran vdout1_17ck1080 FIND v(dout1_17) AT=1090.05n

.meas tran vdout1_18ck1080 FIND v(dout1_18) AT=1090.05n

.meas tran vdout1_19ck1080 FIND v(dout1_19) AT=1090.05n

.meas tran vdout1_0ck1150 FIND v(dout1_0) AT=1160.05n

.meas tran vdout1_1ck1150 FIND v(dout1_1) AT=1160.05n

.meas tran vdout1_2ck1150 FIND v(dout1_2) AT=1160.05n

.meas tran vdout1_3ck1150 FIND v(dout1_3) AT=1160.05n

.meas tran vdout1_4ck1150 FIND v(dout1_4) AT=1160.05n

.meas tran vdout1_5ck1150 FIND v(dout1_5) AT=1160.05n

.meas tran vdout1_6ck1150 FIND v(dout1_6) AT=1160.05n

.meas tran vdout1_7ck1150 FIND v(dout1_7) AT=1160.05n

.meas tran vdout1_8ck1150 FIND v(dout1_8) AT=1160.05n

.meas tran vdout1_9ck1150 FIND v(dout1_9) AT=1160.05n

.meas tran vdout1_10ck1150 FIND v(dout1_10) AT=1160.05n

.meas tran vdout1_11ck1150 FIND v(dout1_11) AT=1160.05n

.meas tran vdout1_12ck1150 FIND v(dout1_12) AT=1160.05n

.meas tran vdout1_13ck1150 FIND v(dout1_13) AT=1160.05n

.meas tran vdout1_14ck1150 FIND v(dout1_14) AT=1160.05n

.meas tran vdout1_15ck1150 FIND v(dout1_15) AT=1160.05n

.meas tran vdout1_16ck1150 FIND v(dout1_16) AT=1160.05n

.meas tran vdout1_17ck1150 FIND v(dout1_17) AT=1160.05n

.meas tran vdout1_18ck1150 FIND v(dout1_18) AT=1160.05n

.meas tran vdout1_19ck1150 FIND v(dout1_19) AT=1160.05n

.meas tran vdout1_0ck1170 FIND v(dout1_0) AT=1180.05n

.meas tran vdout1_1ck1170 FIND v(dout1_1) AT=1180.05n

.meas tran vdout1_2ck1170 FIND v(dout1_2) AT=1180.05n

.meas tran vdout1_3ck1170 FIND v(dout1_3) AT=1180.05n

.meas tran vdout1_4ck1170 FIND v(dout1_4) AT=1180.05n

.meas tran vdout1_5ck1170 FIND v(dout1_5) AT=1180.05n

.meas tran vdout1_6ck1170 FIND v(dout1_6) AT=1180.05n

.meas tran vdout1_7ck1170 FIND v(dout1_7) AT=1180.05n

.meas tran vdout1_8ck1170 FIND v(dout1_8) AT=1180.05n

.meas tran vdout1_9ck1170 FIND v(dout1_9) AT=1180.05n

.meas tran vdout1_10ck1170 FIND v(dout1_10) AT=1180.05n

.meas tran vdout1_11ck1170 FIND v(dout1_11) AT=1180.05n

.meas tran vdout1_12ck1170 FIND v(dout1_12) AT=1180.05n

.meas tran vdout1_13ck1170 FIND v(dout1_13) AT=1180.05n

.meas tran vdout1_14ck1170 FIND v(dout1_14) AT=1180.05n

.meas tran vdout1_15ck1170 FIND v(dout1_15) AT=1180.05n

.meas tran vdout1_16ck1170 FIND v(dout1_16) AT=1180.05n

.meas tran vdout1_17ck1170 FIND v(dout1_17) AT=1180.05n

.meas tran vdout1_18ck1170 FIND v(dout1_18) AT=1180.05n

.meas tran vdout1_19ck1170 FIND v(dout1_19) AT=1180.05n

.meas tran vdout1_0ck1190 FIND v(dout1_0) AT=1200.05n

.meas tran vdout1_1ck1190 FIND v(dout1_1) AT=1200.05n

.meas tran vdout1_2ck1190 FIND v(dout1_2) AT=1200.05n

.meas tran vdout1_3ck1190 FIND v(dout1_3) AT=1200.05n

.meas tran vdout1_4ck1190 FIND v(dout1_4) AT=1200.05n

.meas tran vdout1_5ck1190 FIND v(dout1_5) AT=1200.05n

.meas tran vdout1_6ck1190 FIND v(dout1_6) AT=1200.05n

.meas tran vdout1_7ck1190 FIND v(dout1_7) AT=1200.05n

.meas tran vdout1_8ck1190 FIND v(dout1_8) AT=1200.05n

.meas tran vdout1_9ck1190 FIND v(dout1_9) AT=1200.05n

.meas tran vdout1_10ck1190 FIND v(dout1_10) AT=1200.05n

.meas tran vdout1_11ck1190 FIND v(dout1_11) AT=1200.05n

.meas tran vdout1_12ck1190 FIND v(dout1_12) AT=1200.05n

.meas tran vdout1_13ck1190 FIND v(dout1_13) AT=1200.05n

.meas tran vdout1_14ck1190 FIND v(dout1_14) AT=1200.05n

.meas tran vdout1_15ck1190 FIND v(dout1_15) AT=1200.05n

.meas tran vdout1_16ck1190 FIND v(dout1_16) AT=1200.05n

.meas tran vdout1_17ck1190 FIND v(dout1_17) AT=1200.05n

.meas tran vdout1_18ck1190 FIND v(dout1_18) AT=1200.05n

.meas tran vdout1_19ck1190 FIND v(dout1_19) AT=1200.05n

.meas tran vdout1_0ck1210 FIND v(dout1_0) AT=1220.05n

.meas tran vdout1_1ck1210 FIND v(dout1_1) AT=1220.05n

.meas tran vdout1_2ck1210 FIND v(dout1_2) AT=1220.05n

.meas tran vdout1_3ck1210 FIND v(dout1_3) AT=1220.05n

.meas tran vdout1_4ck1210 FIND v(dout1_4) AT=1220.05n

.meas tran vdout1_5ck1210 FIND v(dout1_5) AT=1220.05n

.meas tran vdout1_6ck1210 FIND v(dout1_6) AT=1220.05n

.meas tran vdout1_7ck1210 FIND v(dout1_7) AT=1220.05n

.meas tran vdout1_8ck1210 FIND v(dout1_8) AT=1220.05n

.meas tran vdout1_9ck1210 FIND v(dout1_9) AT=1220.05n

.meas tran vdout1_10ck1210 FIND v(dout1_10) AT=1220.05n

.meas tran vdout1_11ck1210 FIND v(dout1_11) AT=1220.05n

.meas tran vdout1_12ck1210 FIND v(dout1_12) AT=1220.05n

.meas tran vdout1_13ck1210 FIND v(dout1_13) AT=1220.05n

.meas tran vdout1_14ck1210 FIND v(dout1_14) AT=1220.05n

.meas tran vdout1_15ck1210 FIND v(dout1_15) AT=1220.05n

.meas tran vdout1_16ck1210 FIND v(dout1_16) AT=1220.05n

.meas tran vdout1_17ck1210 FIND v(dout1_17) AT=1220.05n

.meas tran vdout1_18ck1210 FIND v(dout1_18) AT=1220.05n

.meas tran vdout1_19ck1210 FIND v(dout1_19) AT=1220.05n

.meas tran vdout1_0ck1220 FIND v(dout1_0) AT=1230.05n

.meas tran vdout1_1ck1220 FIND v(dout1_1) AT=1230.05n

.meas tran vdout1_2ck1220 FIND v(dout1_2) AT=1230.05n

.meas tran vdout1_3ck1220 FIND v(dout1_3) AT=1230.05n

.meas tran vdout1_4ck1220 FIND v(dout1_4) AT=1230.05n

.meas tran vdout1_5ck1220 FIND v(dout1_5) AT=1230.05n

.meas tran vdout1_6ck1220 FIND v(dout1_6) AT=1230.05n

.meas tran vdout1_7ck1220 FIND v(dout1_7) AT=1230.05n

.meas tran vdout1_8ck1220 FIND v(dout1_8) AT=1230.05n

.meas tran vdout1_9ck1220 FIND v(dout1_9) AT=1230.05n

.meas tran vdout1_10ck1220 FIND v(dout1_10) AT=1230.05n

.meas tran vdout1_11ck1220 FIND v(dout1_11) AT=1230.05n

.meas tran vdout1_12ck1220 FIND v(dout1_12) AT=1230.05n

.meas tran vdout1_13ck1220 FIND v(dout1_13) AT=1230.05n

.meas tran vdout1_14ck1220 FIND v(dout1_14) AT=1230.05n

.meas tran vdout1_15ck1220 FIND v(dout1_15) AT=1230.05n

.meas tran vdout1_16ck1220 FIND v(dout1_16) AT=1230.05n

.meas tran vdout1_17ck1220 FIND v(dout1_17) AT=1230.05n

.meas tran vdout1_18ck1220 FIND v(dout1_18) AT=1230.05n

.meas tran vdout1_19ck1220 FIND v(dout1_19) AT=1230.05n

.meas tran vdout1_0ck1240 FIND v(dout1_0) AT=1250.05n

.meas tran vdout1_1ck1240 FIND v(dout1_1) AT=1250.05n

.meas tran vdout1_2ck1240 FIND v(dout1_2) AT=1250.05n

.meas tran vdout1_3ck1240 FIND v(dout1_3) AT=1250.05n

.meas tran vdout1_4ck1240 FIND v(dout1_4) AT=1250.05n

.meas tran vdout1_5ck1240 FIND v(dout1_5) AT=1250.05n

.meas tran vdout1_6ck1240 FIND v(dout1_6) AT=1250.05n

.meas tran vdout1_7ck1240 FIND v(dout1_7) AT=1250.05n

.meas tran vdout1_8ck1240 FIND v(dout1_8) AT=1250.05n

.meas tran vdout1_9ck1240 FIND v(dout1_9) AT=1250.05n

.meas tran vdout1_10ck1240 FIND v(dout1_10) AT=1250.05n

.meas tran vdout1_11ck1240 FIND v(dout1_11) AT=1250.05n

.meas tran vdout1_12ck1240 FIND v(dout1_12) AT=1250.05n

.meas tran vdout1_13ck1240 FIND v(dout1_13) AT=1250.05n

.meas tran vdout1_14ck1240 FIND v(dout1_14) AT=1250.05n

.meas tran vdout1_15ck1240 FIND v(dout1_15) AT=1250.05n

.meas tran vdout1_16ck1240 FIND v(dout1_16) AT=1250.05n

.meas tran vdout1_17ck1240 FIND v(dout1_17) AT=1250.05n

.meas tran vdout1_18ck1240 FIND v(dout1_18) AT=1250.05n

.meas tran vdout1_19ck1240 FIND v(dout1_19) AT=1250.05n

.meas tran vdout1_0ck1250 FIND v(dout1_0) AT=1260.05n

.meas tran vdout1_1ck1250 FIND v(dout1_1) AT=1260.05n

.meas tran vdout1_2ck1250 FIND v(dout1_2) AT=1260.05n

.meas tran vdout1_3ck1250 FIND v(dout1_3) AT=1260.05n

.meas tran vdout1_4ck1250 FIND v(dout1_4) AT=1260.05n

.meas tran vdout1_5ck1250 FIND v(dout1_5) AT=1260.05n

.meas tran vdout1_6ck1250 FIND v(dout1_6) AT=1260.05n

.meas tran vdout1_7ck1250 FIND v(dout1_7) AT=1260.05n

.meas tran vdout1_8ck1250 FIND v(dout1_8) AT=1260.05n

.meas tran vdout1_9ck1250 FIND v(dout1_9) AT=1260.05n

.meas tran vdout1_10ck1250 FIND v(dout1_10) AT=1260.05n

.meas tran vdout1_11ck1250 FIND v(dout1_11) AT=1260.05n

.meas tran vdout1_12ck1250 FIND v(dout1_12) AT=1260.05n

.meas tran vdout1_13ck1250 FIND v(dout1_13) AT=1260.05n

.meas tran vdout1_14ck1250 FIND v(dout1_14) AT=1260.05n

.meas tran vdout1_15ck1250 FIND v(dout1_15) AT=1260.05n

.meas tran vdout1_16ck1250 FIND v(dout1_16) AT=1260.05n

.meas tran vdout1_17ck1250 FIND v(dout1_17) AT=1260.05n

.meas tran vdout1_18ck1250 FIND v(dout1_18) AT=1260.05n

.meas tran vdout1_19ck1250 FIND v(dout1_19) AT=1260.05n

.meas tran vdout1_0ck1280 FIND v(dout1_0) AT=1290.05n

.meas tran vdout1_1ck1280 FIND v(dout1_1) AT=1290.05n

.meas tran vdout1_2ck1280 FIND v(dout1_2) AT=1290.05n

.meas tran vdout1_3ck1280 FIND v(dout1_3) AT=1290.05n

.meas tran vdout1_4ck1280 FIND v(dout1_4) AT=1290.05n

.meas tran vdout1_5ck1280 FIND v(dout1_5) AT=1290.05n

.meas tran vdout1_6ck1280 FIND v(dout1_6) AT=1290.05n

.meas tran vdout1_7ck1280 FIND v(dout1_7) AT=1290.05n

.meas tran vdout1_8ck1280 FIND v(dout1_8) AT=1290.05n

.meas tran vdout1_9ck1280 FIND v(dout1_9) AT=1290.05n

.meas tran vdout1_10ck1280 FIND v(dout1_10) AT=1290.05n

.meas tran vdout1_11ck1280 FIND v(dout1_11) AT=1290.05n

.meas tran vdout1_12ck1280 FIND v(dout1_12) AT=1290.05n

.meas tran vdout1_13ck1280 FIND v(dout1_13) AT=1290.05n

.meas tran vdout1_14ck1280 FIND v(dout1_14) AT=1290.05n

.meas tran vdout1_15ck1280 FIND v(dout1_15) AT=1290.05n

.meas tran vdout1_16ck1280 FIND v(dout1_16) AT=1290.05n

.meas tran vdout1_17ck1280 FIND v(dout1_17) AT=1290.05n

.meas tran vdout1_18ck1280 FIND v(dout1_18) AT=1290.05n

.meas tran vdout1_19ck1280 FIND v(dout1_19) AT=1290.05n

.meas tran vdout1_0ck1320 FIND v(dout1_0) AT=1330.05n

.meas tran vdout1_1ck1320 FIND v(dout1_1) AT=1330.05n

.meas tran vdout1_2ck1320 FIND v(dout1_2) AT=1330.05n

.meas tran vdout1_3ck1320 FIND v(dout1_3) AT=1330.05n

.meas tran vdout1_4ck1320 FIND v(dout1_4) AT=1330.05n

.meas tran vdout1_5ck1320 FIND v(dout1_5) AT=1330.05n

.meas tran vdout1_6ck1320 FIND v(dout1_6) AT=1330.05n

.meas tran vdout1_7ck1320 FIND v(dout1_7) AT=1330.05n

.meas tran vdout1_8ck1320 FIND v(dout1_8) AT=1330.05n

.meas tran vdout1_9ck1320 FIND v(dout1_9) AT=1330.05n

.meas tran vdout1_10ck1320 FIND v(dout1_10) AT=1330.05n

.meas tran vdout1_11ck1320 FIND v(dout1_11) AT=1330.05n

.meas tran vdout1_12ck1320 FIND v(dout1_12) AT=1330.05n

.meas tran vdout1_13ck1320 FIND v(dout1_13) AT=1330.05n

.meas tran vdout1_14ck1320 FIND v(dout1_14) AT=1330.05n

.meas tran vdout1_15ck1320 FIND v(dout1_15) AT=1330.05n

.meas tran vdout1_16ck1320 FIND v(dout1_16) AT=1330.05n

.meas tran vdout1_17ck1320 FIND v(dout1_17) AT=1330.05n

.meas tran vdout1_18ck1320 FIND v(dout1_18) AT=1330.05n

.meas tran vdout1_19ck1320 FIND v(dout1_19) AT=1330.05n

.meas tran vdout1_0ck1330 FIND v(dout1_0) AT=1340.05n

.meas tran vdout1_1ck1330 FIND v(dout1_1) AT=1340.05n

.meas tran vdout1_2ck1330 FIND v(dout1_2) AT=1340.05n

.meas tran vdout1_3ck1330 FIND v(dout1_3) AT=1340.05n

.meas tran vdout1_4ck1330 FIND v(dout1_4) AT=1340.05n

.meas tran vdout1_5ck1330 FIND v(dout1_5) AT=1340.05n

.meas tran vdout1_6ck1330 FIND v(dout1_6) AT=1340.05n

.meas tran vdout1_7ck1330 FIND v(dout1_7) AT=1340.05n

.meas tran vdout1_8ck1330 FIND v(dout1_8) AT=1340.05n

.meas tran vdout1_9ck1330 FIND v(dout1_9) AT=1340.05n

.meas tran vdout1_10ck1330 FIND v(dout1_10) AT=1340.05n

.meas tran vdout1_11ck1330 FIND v(dout1_11) AT=1340.05n

.meas tran vdout1_12ck1330 FIND v(dout1_12) AT=1340.05n

.meas tran vdout1_13ck1330 FIND v(dout1_13) AT=1340.05n

.meas tran vdout1_14ck1330 FIND v(dout1_14) AT=1340.05n

.meas tran vdout1_15ck1330 FIND v(dout1_15) AT=1340.05n

.meas tran vdout1_16ck1330 FIND v(dout1_16) AT=1340.05n

.meas tran vdout1_17ck1330 FIND v(dout1_17) AT=1340.05n

.meas tran vdout1_18ck1330 FIND v(dout1_18) AT=1340.05n

.meas tran vdout1_19ck1330 FIND v(dout1_19) AT=1340.05n

.meas tran vdout1_0ck1340 FIND v(dout1_0) AT=1350.05n

.meas tran vdout1_1ck1340 FIND v(dout1_1) AT=1350.05n

.meas tran vdout1_2ck1340 FIND v(dout1_2) AT=1350.05n

.meas tran vdout1_3ck1340 FIND v(dout1_3) AT=1350.05n

.meas tran vdout1_4ck1340 FIND v(dout1_4) AT=1350.05n

.meas tran vdout1_5ck1340 FIND v(dout1_5) AT=1350.05n

.meas tran vdout1_6ck1340 FIND v(dout1_6) AT=1350.05n

.meas tran vdout1_7ck1340 FIND v(dout1_7) AT=1350.05n

.meas tran vdout1_8ck1340 FIND v(dout1_8) AT=1350.05n

.meas tran vdout1_9ck1340 FIND v(dout1_9) AT=1350.05n

.meas tran vdout1_10ck1340 FIND v(dout1_10) AT=1350.05n

.meas tran vdout1_11ck1340 FIND v(dout1_11) AT=1350.05n

.meas tran vdout1_12ck1340 FIND v(dout1_12) AT=1350.05n

.meas tran vdout1_13ck1340 FIND v(dout1_13) AT=1350.05n

.meas tran vdout1_14ck1340 FIND v(dout1_14) AT=1350.05n

.meas tran vdout1_15ck1340 FIND v(dout1_15) AT=1350.05n

.meas tran vdout1_16ck1340 FIND v(dout1_16) AT=1350.05n

.meas tran vdout1_17ck1340 FIND v(dout1_17) AT=1350.05n

.meas tran vdout1_18ck1340 FIND v(dout1_18) AT=1350.05n

.meas tran vdout1_19ck1340 FIND v(dout1_19) AT=1350.05n

.meas tran vdout1_0ck1380 FIND v(dout1_0) AT=1390.05n

.meas tran vdout1_1ck1380 FIND v(dout1_1) AT=1390.05n

.meas tran vdout1_2ck1380 FIND v(dout1_2) AT=1390.05n

.meas tran vdout1_3ck1380 FIND v(dout1_3) AT=1390.05n

.meas tran vdout1_4ck1380 FIND v(dout1_4) AT=1390.05n

.meas tran vdout1_5ck1380 FIND v(dout1_5) AT=1390.05n

.meas tran vdout1_6ck1380 FIND v(dout1_6) AT=1390.05n

.meas tran vdout1_7ck1380 FIND v(dout1_7) AT=1390.05n

.meas tran vdout1_8ck1380 FIND v(dout1_8) AT=1390.05n

.meas tran vdout1_9ck1380 FIND v(dout1_9) AT=1390.05n

.meas tran vdout1_10ck1380 FIND v(dout1_10) AT=1390.05n

.meas tran vdout1_11ck1380 FIND v(dout1_11) AT=1390.05n

.meas tran vdout1_12ck1380 FIND v(dout1_12) AT=1390.05n

.meas tran vdout1_13ck1380 FIND v(dout1_13) AT=1390.05n

.meas tran vdout1_14ck1380 FIND v(dout1_14) AT=1390.05n

.meas tran vdout1_15ck1380 FIND v(dout1_15) AT=1390.05n

.meas tran vdout1_16ck1380 FIND v(dout1_16) AT=1390.05n

.meas tran vdout1_17ck1380 FIND v(dout1_17) AT=1390.05n

.meas tran vdout1_18ck1380 FIND v(dout1_18) AT=1390.05n

.meas tran vdout1_19ck1380 FIND v(dout1_19) AT=1390.05n

.meas tran vdout1_0ck1400 FIND v(dout1_0) AT=1410.05n

.meas tran vdout1_1ck1400 FIND v(dout1_1) AT=1410.05n

.meas tran vdout1_2ck1400 FIND v(dout1_2) AT=1410.05n

.meas tran vdout1_3ck1400 FIND v(dout1_3) AT=1410.05n

.meas tran vdout1_4ck1400 FIND v(dout1_4) AT=1410.05n

.meas tran vdout1_5ck1400 FIND v(dout1_5) AT=1410.05n

.meas tran vdout1_6ck1400 FIND v(dout1_6) AT=1410.05n

.meas tran vdout1_7ck1400 FIND v(dout1_7) AT=1410.05n

.meas tran vdout1_8ck1400 FIND v(dout1_8) AT=1410.05n

.meas tran vdout1_9ck1400 FIND v(dout1_9) AT=1410.05n

.meas tran vdout1_10ck1400 FIND v(dout1_10) AT=1410.05n

.meas tran vdout1_11ck1400 FIND v(dout1_11) AT=1410.05n

.meas tran vdout1_12ck1400 FIND v(dout1_12) AT=1410.05n

.meas tran vdout1_13ck1400 FIND v(dout1_13) AT=1410.05n

.meas tran vdout1_14ck1400 FIND v(dout1_14) AT=1410.05n

.meas tran vdout1_15ck1400 FIND v(dout1_15) AT=1410.05n

.meas tran vdout1_16ck1400 FIND v(dout1_16) AT=1410.05n

.meas tran vdout1_17ck1400 FIND v(dout1_17) AT=1410.05n

.meas tran vdout1_18ck1400 FIND v(dout1_18) AT=1410.05n

.meas tran vdout1_19ck1400 FIND v(dout1_19) AT=1410.05n

.meas tran vdout1_0ck1420 FIND v(dout1_0) AT=1430.05n

.meas tran vdout1_1ck1420 FIND v(dout1_1) AT=1430.05n

.meas tran vdout1_2ck1420 FIND v(dout1_2) AT=1430.05n

.meas tran vdout1_3ck1420 FIND v(dout1_3) AT=1430.05n

.meas tran vdout1_4ck1420 FIND v(dout1_4) AT=1430.05n

.meas tran vdout1_5ck1420 FIND v(dout1_5) AT=1430.05n

.meas tran vdout1_6ck1420 FIND v(dout1_6) AT=1430.05n

.meas tran vdout1_7ck1420 FIND v(dout1_7) AT=1430.05n

.meas tran vdout1_8ck1420 FIND v(dout1_8) AT=1430.05n

.meas tran vdout1_9ck1420 FIND v(dout1_9) AT=1430.05n

.meas tran vdout1_10ck1420 FIND v(dout1_10) AT=1430.05n

.meas tran vdout1_11ck1420 FIND v(dout1_11) AT=1430.05n

.meas tran vdout1_12ck1420 FIND v(dout1_12) AT=1430.05n

.meas tran vdout1_13ck1420 FIND v(dout1_13) AT=1430.05n

.meas tran vdout1_14ck1420 FIND v(dout1_14) AT=1430.05n

.meas tran vdout1_15ck1420 FIND v(dout1_15) AT=1430.05n

.meas tran vdout1_16ck1420 FIND v(dout1_16) AT=1430.05n

.meas tran vdout1_17ck1420 FIND v(dout1_17) AT=1430.05n

.meas tran vdout1_18ck1420 FIND v(dout1_18) AT=1430.05n

.meas tran vdout1_19ck1420 FIND v(dout1_19) AT=1430.05n

.meas tran vdout1_0ck1460 FIND v(dout1_0) AT=1470.05n

.meas tran vdout1_1ck1460 FIND v(dout1_1) AT=1470.05n

.meas tran vdout1_2ck1460 FIND v(dout1_2) AT=1470.05n

.meas tran vdout1_3ck1460 FIND v(dout1_3) AT=1470.05n

.meas tran vdout1_4ck1460 FIND v(dout1_4) AT=1470.05n

.meas tran vdout1_5ck1460 FIND v(dout1_5) AT=1470.05n

.meas tran vdout1_6ck1460 FIND v(dout1_6) AT=1470.05n

.meas tran vdout1_7ck1460 FIND v(dout1_7) AT=1470.05n

.meas tran vdout1_8ck1460 FIND v(dout1_8) AT=1470.05n

.meas tran vdout1_9ck1460 FIND v(dout1_9) AT=1470.05n

.meas tran vdout1_10ck1460 FIND v(dout1_10) AT=1470.05n

.meas tran vdout1_11ck1460 FIND v(dout1_11) AT=1470.05n

.meas tran vdout1_12ck1460 FIND v(dout1_12) AT=1470.05n

.meas tran vdout1_13ck1460 FIND v(dout1_13) AT=1470.05n

.meas tran vdout1_14ck1460 FIND v(dout1_14) AT=1470.05n

.meas tran vdout1_15ck1460 FIND v(dout1_15) AT=1470.05n

.meas tran vdout1_16ck1460 FIND v(dout1_16) AT=1470.05n

.meas tran vdout1_17ck1460 FIND v(dout1_17) AT=1470.05n

.meas tran vdout1_18ck1460 FIND v(dout1_18) AT=1470.05n

.meas tran vdout1_19ck1460 FIND v(dout1_19) AT=1470.05n

.meas tran vdout1_0ck1490 FIND v(dout1_0) AT=1500.05n

.meas tran vdout1_1ck1490 FIND v(dout1_1) AT=1500.05n

.meas tran vdout1_2ck1490 FIND v(dout1_2) AT=1500.05n

.meas tran vdout1_3ck1490 FIND v(dout1_3) AT=1500.05n

.meas tran vdout1_4ck1490 FIND v(dout1_4) AT=1500.05n

.meas tran vdout1_5ck1490 FIND v(dout1_5) AT=1500.05n

.meas tran vdout1_6ck1490 FIND v(dout1_6) AT=1500.05n

.meas tran vdout1_7ck1490 FIND v(dout1_7) AT=1500.05n

.meas tran vdout1_8ck1490 FIND v(dout1_8) AT=1500.05n

.meas tran vdout1_9ck1490 FIND v(dout1_9) AT=1500.05n

.meas tran vdout1_10ck1490 FIND v(dout1_10) AT=1500.05n

.meas tran vdout1_11ck1490 FIND v(dout1_11) AT=1500.05n

.meas tran vdout1_12ck1490 FIND v(dout1_12) AT=1500.05n

.meas tran vdout1_13ck1490 FIND v(dout1_13) AT=1500.05n

.meas tran vdout1_14ck1490 FIND v(dout1_14) AT=1500.05n

.meas tran vdout1_15ck1490 FIND v(dout1_15) AT=1500.05n

.meas tran vdout1_16ck1490 FIND v(dout1_16) AT=1500.05n

.meas tran vdout1_17ck1490 FIND v(dout1_17) AT=1500.05n

.meas tran vdout1_18ck1490 FIND v(dout1_18) AT=1500.05n

.meas tran vdout1_19ck1490 FIND v(dout1_19) AT=1500.05n

.meas tran vdout1_0ck1550 FIND v(dout1_0) AT=1560.05n

.meas tran vdout1_1ck1550 FIND v(dout1_1) AT=1560.05n

.meas tran vdout1_2ck1550 FIND v(dout1_2) AT=1560.05n

.meas tran vdout1_3ck1550 FIND v(dout1_3) AT=1560.05n

.meas tran vdout1_4ck1550 FIND v(dout1_4) AT=1560.05n

.meas tran vdout1_5ck1550 FIND v(dout1_5) AT=1560.05n

.meas tran vdout1_6ck1550 FIND v(dout1_6) AT=1560.05n

.meas tran vdout1_7ck1550 FIND v(dout1_7) AT=1560.05n

.meas tran vdout1_8ck1550 FIND v(dout1_8) AT=1560.05n

.meas tran vdout1_9ck1550 FIND v(dout1_9) AT=1560.05n

.meas tran vdout1_10ck1550 FIND v(dout1_10) AT=1560.05n

.meas tran vdout1_11ck1550 FIND v(dout1_11) AT=1560.05n

.meas tran vdout1_12ck1550 FIND v(dout1_12) AT=1560.05n

.meas tran vdout1_13ck1550 FIND v(dout1_13) AT=1560.05n

.meas tran vdout1_14ck1550 FIND v(dout1_14) AT=1560.05n

.meas tran vdout1_15ck1550 FIND v(dout1_15) AT=1560.05n

.meas tran vdout1_16ck1550 FIND v(dout1_16) AT=1560.05n

.meas tran vdout1_17ck1550 FIND v(dout1_17) AT=1560.05n

.meas tran vdout1_18ck1550 FIND v(dout1_18) AT=1560.05n

.meas tran vdout1_19ck1550 FIND v(dout1_19) AT=1560.05n

.meas tran vdout1_0ck1570 FIND v(dout1_0) AT=1580.05n

.meas tran vdout1_1ck1570 FIND v(dout1_1) AT=1580.05n

.meas tran vdout1_2ck1570 FIND v(dout1_2) AT=1580.05n

.meas tran vdout1_3ck1570 FIND v(dout1_3) AT=1580.05n

.meas tran vdout1_4ck1570 FIND v(dout1_4) AT=1580.05n

.meas tran vdout1_5ck1570 FIND v(dout1_5) AT=1580.05n

.meas tran vdout1_6ck1570 FIND v(dout1_6) AT=1580.05n

.meas tran vdout1_7ck1570 FIND v(dout1_7) AT=1580.05n

.meas tran vdout1_8ck1570 FIND v(dout1_8) AT=1580.05n

.meas tran vdout1_9ck1570 FIND v(dout1_9) AT=1580.05n

.meas tran vdout1_10ck1570 FIND v(dout1_10) AT=1580.05n

.meas tran vdout1_11ck1570 FIND v(dout1_11) AT=1580.05n

.meas tran vdout1_12ck1570 FIND v(dout1_12) AT=1580.05n

.meas tran vdout1_13ck1570 FIND v(dout1_13) AT=1580.05n

.meas tran vdout1_14ck1570 FIND v(dout1_14) AT=1580.05n

.meas tran vdout1_15ck1570 FIND v(dout1_15) AT=1580.05n

.meas tran vdout1_16ck1570 FIND v(dout1_16) AT=1580.05n

.meas tran vdout1_17ck1570 FIND v(dout1_17) AT=1580.05n

.meas tran vdout1_18ck1570 FIND v(dout1_18) AT=1580.05n

.meas tran vdout1_19ck1570 FIND v(dout1_19) AT=1580.05n

.meas tran vdout1_0ck1600 FIND v(dout1_0) AT=1610.05n

.meas tran vdout1_1ck1600 FIND v(dout1_1) AT=1610.05n

.meas tran vdout1_2ck1600 FIND v(dout1_2) AT=1610.05n

.meas tran vdout1_3ck1600 FIND v(dout1_3) AT=1610.05n

.meas tran vdout1_4ck1600 FIND v(dout1_4) AT=1610.05n

.meas tran vdout1_5ck1600 FIND v(dout1_5) AT=1610.05n

.meas tran vdout1_6ck1600 FIND v(dout1_6) AT=1610.05n

.meas tran vdout1_7ck1600 FIND v(dout1_7) AT=1610.05n

.meas tran vdout1_8ck1600 FIND v(dout1_8) AT=1610.05n

.meas tran vdout1_9ck1600 FIND v(dout1_9) AT=1610.05n

.meas tran vdout1_10ck1600 FIND v(dout1_10) AT=1610.05n

.meas tran vdout1_11ck1600 FIND v(dout1_11) AT=1610.05n

.meas tran vdout1_12ck1600 FIND v(dout1_12) AT=1610.05n

.meas tran vdout1_13ck1600 FIND v(dout1_13) AT=1610.05n

.meas tran vdout1_14ck1600 FIND v(dout1_14) AT=1610.05n

.meas tran vdout1_15ck1600 FIND v(dout1_15) AT=1610.05n

.meas tran vdout1_16ck1600 FIND v(dout1_16) AT=1610.05n

.meas tran vdout1_17ck1600 FIND v(dout1_17) AT=1610.05n

.meas tran vdout1_18ck1600 FIND v(dout1_18) AT=1610.05n

.meas tran vdout1_19ck1600 FIND v(dout1_19) AT=1610.05n

.meas tran vdout1_0ck1610 FIND v(dout1_0) AT=1620.05n

.meas tran vdout1_1ck1610 FIND v(dout1_1) AT=1620.05n

.meas tran vdout1_2ck1610 FIND v(dout1_2) AT=1620.05n

.meas tran vdout1_3ck1610 FIND v(dout1_3) AT=1620.05n

.meas tran vdout1_4ck1610 FIND v(dout1_4) AT=1620.05n

.meas tran vdout1_5ck1610 FIND v(dout1_5) AT=1620.05n

.meas tran vdout1_6ck1610 FIND v(dout1_6) AT=1620.05n

.meas tran vdout1_7ck1610 FIND v(dout1_7) AT=1620.05n

.meas tran vdout1_8ck1610 FIND v(dout1_8) AT=1620.05n

.meas tran vdout1_9ck1610 FIND v(dout1_9) AT=1620.05n

.meas tran vdout1_10ck1610 FIND v(dout1_10) AT=1620.05n

.meas tran vdout1_11ck1610 FIND v(dout1_11) AT=1620.05n

.meas tran vdout1_12ck1610 FIND v(dout1_12) AT=1620.05n

.meas tran vdout1_13ck1610 FIND v(dout1_13) AT=1620.05n

.meas tran vdout1_14ck1610 FIND v(dout1_14) AT=1620.05n

.meas tran vdout1_15ck1610 FIND v(dout1_15) AT=1620.05n

.meas tran vdout1_16ck1610 FIND v(dout1_16) AT=1620.05n

.meas tran vdout1_17ck1610 FIND v(dout1_17) AT=1620.05n

.meas tran vdout1_18ck1610 FIND v(dout1_18) AT=1620.05n

.meas tran vdout1_19ck1610 FIND v(dout1_19) AT=1620.05n

.meas tran vdout1_0ck1640 FIND v(dout1_0) AT=1650.05n

.meas tran vdout1_1ck1640 FIND v(dout1_1) AT=1650.05n

.meas tran vdout1_2ck1640 FIND v(dout1_2) AT=1650.05n

.meas tran vdout1_3ck1640 FIND v(dout1_3) AT=1650.05n

.meas tran vdout1_4ck1640 FIND v(dout1_4) AT=1650.05n

.meas tran vdout1_5ck1640 FIND v(dout1_5) AT=1650.05n

.meas tran vdout1_6ck1640 FIND v(dout1_6) AT=1650.05n

.meas tran vdout1_7ck1640 FIND v(dout1_7) AT=1650.05n

.meas tran vdout1_8ck1640 FIND v(dout1_8) AT=1650.05n

.meas tran vdout1_9ck1640 FIND v(dout1_9) AT=1650.05n

.meas tran vdout1_10ck1640 FIND v(dout1_10) AT=1650.05n

.meas tran vdout1_11ck1640 FIND v(dout1_11) AT=1650.05n

.meas tran vdout1_12ck1640 FIND v(dout1_12) AT=1650.05n

.meas tran vdout1_13ck1640 FIND v(dout1_13) AT=1650.05n

.meas tran vdout1_14ck1640 FIND v(dout1_14) AT=1650.05n

.meas tran vdout1_15ck1640 FIND v(dout1_15) AT=1650.05n

.meas tran vdout1_16ck1640 FIND v(dout1_16) AT=1650.05n

.meas tran vdout1_17ck1640 FIND v(dout1_17) AT=1650.05n

.meas tran vdout1_18ck1640 FIND v(dout1_18) AT=1650.05n

.meas tran vdout1_19ck1640 FIND v(dout1_19) AT=1650.05n

.meas tran vdout1_0ck1690 FIND v(dout1_0) AT=1700.05n

.meas tran vdout1_1ck1690 FIND v(dout1_1) AT=1700.05n

.meas tran vdout1_2ck1690 FIND v(dout1_2) AT=1700.05n

.meas tran vdout1_3ck1690 FIND v(dout1_3) AT=1700.05n

.meas tran vdout1_4ck1690 FIND v(dout1_4) AT=1700.05n

.meas tran vdout1_5ck1690 FIND v(dout1_5) AT=1700.05n

.meas tran vdout1_6ck1690 FIND v(dout1_6) AT=1700.05n

.meas tran vdout1_7ck1690 FIND v(dout1_7) AT=1700.05n

.meas tran vdout1_8ck1690 FIND v(dout1_8) AT=1700.05n

.meas tran vdout1_9ck1690 FIND v(dout1_9) AT=1700.05n

.meas tran vdout1_10ck1690 FIND v(dout1_10) AT=1700.05n

.meas tran vdout1_11ck1690 FIND v(dout1_11) AT=1700.05n

.meas tran vdout1_12ck1690 FIND v(dout1_12) AT=1700.05n

.meas tran vdout1_13ck1690 FIND v(dout1_13) AT=1700.05n

.meas tran vdout1_14ck1690 FIND v(dout1_14) AT=1700.05n

.meas tran vdout1_15ck1690 FIND v(dout1_15) AT=1700.05n

.meas tran vdout1_16ck1690 FIND v(dout1_16) AT=1700.05n

.meas tran vdout1_17ck1690 FIND v(dout1_17) AT=1700.05n

.meas tran vdout1_18ck1690 FIND v(dout1_18) AT=1700.05n

.meas tran vdout1_19ck1690 FIND v(dout1_19) AT=1700.05n

.meas tran vdout1_0ck1700 FIND v(dout1_0) AT=1710.05n

.meas tran vdout1_1ck1700 FIND v(dout1_1) AT=1710.05n

.meas tran vdout1_2ck1700 FIND v(dout1_2) AT=1710.05n

.meas tran vdout1_3ck1700 FIND v(dout1_3) AT=1710.05n

.meas tran vdout1_4ck1700 FIND v(dout1_4) AT=1710.05n

.meas tran vdout1_5ck1700 FIND v(dout1_5) AT=1710.05n

.meas tran vdout1_6ck1700 FIND v(dout1_6) AT=1710.05n

.meas tran vdout1_7ck1700 FIND v(dout1_7) AT=1710.05n

.meas tran vdout1_8ck1700 FIND v(dout1_8) AT=1710.05n

.meas tran vdout1_9ck1700 FIND v(dout1_9) AT=1710.05n

.meas tran vdout1_10ck1700 FIND v(dout1_10) AT=1710.05n

.meas tran vdout1_11ck1700 FIND v(dout1_11) AT=1710.05n

.meas tran vdout1_12ck1700 FIND v(dout1_12) AT=1710.05n

.meas tran vdout1_13ck1700 FIND v(dout1_13) AT=1710.05n

.meas tran vdout1_14ck1700 FIND v(dout1_14) AT=1710.05n

.meas tran vdout1_15ck1700 FIND v(dout1_15) AT=1710.05n

.meas tran vdout1_16ck1700 FIND v(dout1_16) AT=1710.05n

.meas tran vdout1_17ck1700 FIND v(dout1_17) AT=1710.05n

.meas tran vdout1_18ck1700 FIND v(dout1_18) AT=1710.05n

.meas tran vdout1_19ck1700 FIND v(dout1_19) AT=1710.05n

.meas tran vdout1_0ck1710 FIND v(dout1_0) AT=1720.05n

.meas tran vdout1_1ck1710 FIND v(dout1_1) AT=1720.05n

.meas tran vdout1_2ck1710 FIND v(dout1_2) AT=1720.05n

.meas tran vdout1_3ck1710 FIND v(dout1_3) AT=1720.05n

.meas tran vdout1_4ck1710 FIND v(dout1_4) AT=1720.05n

.meas tran vdout1_5ck1710 FIND v(dout1_5) AT=1720.05n

.meas tran vdout1_6ck1710 FIND v(dout1_6) AT=1720.05n

.meas tran vdout1_7ck1710 FIND v(dout1_7) AT=1720.05n

.meas tran vdout1_8ck1710 FIND v(dout1_8) AT=1720.05n

.meas tran vdout1_9ck1710 FIND v(dout1_9) AT=1720.05n

.meas tran vdout1_10ck1710 FIND v(dout1_10) AT=1720.05n

.meas tran vdout1_11ck1710 FIND v(dout1_11) AT=1720.05n

.meas tran vdout1_12ck1710 FIND v(dout1_12) AT=1720.05n

.meas tran vdout1_13ck1710 FIND v(dout1_13) AT=1720.05n

.meas tran vdout1_14ck1710 FIND v(dout1_14) AT=1720.05n

.meas tran vdout1_15ck1710 FIND v(dout1_15) AT=1720.05n

.meas tran vdout1_16ck1710 FIND v(dout1_16) AT=1720.05n

.meas tran vdout1_17ck1710 FIND v(dout1_17) AT=1720.05n

.meas tran vdout1_18ck1710 FIND v(dout1_18) AT=1720.05n

.meas tran vdout1_19ck1710 FIND v(dout1_19) AT=1720.05n

.meas tran vdout1_0ck1750 FIND v(dout1_0) AT=1760.05n

.meas tran vdout1_1ck1750 FIND v(dout1_1) AT=1760.05n

.meas tran vdout1_2ck1750 FIND v(dout1_2) AT=1760.05n

.meas tran vdout1_3ck1750 FIND v(dout1_3) AT=1760.05n

.meas tran vdout1_4ck1750 FIND v(dout1_4) AT=1760.05n

.meas tran vdout1_5ck1750 FIND v(dout1_5) AT=1760.05n

.meas tran vdout1_6ck1750 FIND v(dout1_6) AT=1760.05n

.meas tran vdout1_7ck1750 FIND v(dout1_7) AT=1760.05n

.meas tran vdout1_8ck1750 FIND v(dout1_8) AT=1760.05n

.meas tran vdout1_9ck1750 FIND v(dout1_9) AT=1760.05n

.meas tran vdout1_10ck1750 FIND v(dout1_10) AT=1760.05n

.meas tran vdout1_11ck1750 FIND v(dout1_11) AT=1760.05n

.meas tran vdout1_12ck1750 FIND v(dout1_12) AT=1760.05n

.meas tran vdout1_13ck1750 FIND v(dout1_13) AT=1760.05n

.meas tran vdout1_14ck1750 FIND v(dout1_14) AT=1760.05n

.meas tran vdout1_15ck1750 FIND v(dout1_15) AT=1760.05n

.meas tran vdout1_16ck1750 FIND v(dout1_16) AT=1760.05n

.meas tran vdout1_17ck1750 FIND v(dout1_17) AT=1760.05n

.meas tran vdout1_18ck1750 FIND v(dout1_18) AT=1760.05n

.meas tran vdout1_19ck1750 FIND v(dout1_19) AT=1760.05n

.meas tran vdout1_0ck1780 FIND v(dout1_0) AT=1790.05n

.meas tran vdout1_1ck1780 FIND v(dout1_1) AT=1790.05n

.meas tran vdout1_2ck1780 FIND v(dout1_2) AT=1790.05n

.meas tran vdout1_3ck1780 FIND v(dout1_3) AT=1790.05n

.meas tran vdout1_4ck1780 FIND v(dout1_4) AT=1790.05n

.meas tran vdout1_5ck1780 FIND v(dout1_5) AT=1790.05n

.meas tran vdout1_6ck1780 FIND v(dout1_6) AT=1790.05n

.meas tran vdout1_7ck1780 FIND v(dout1_7) AT=1790.05n

.meas tran vdout1_8ck1780 FIND v(dout1_8) AT=1790.05n

.meas tran vdout1_9ck1780 FIND v(dout1_9) AT=1790.05n

.meas tran vdout1_10ck1780 FIND v(dout1_10) AT=1790.05n

.meas tran vdout1_11ck1780 FIND v(dout1_11) AT=1790.05n

.meas tran vdout1_12ck1780 FIND v(dout1_12) AT=1790.05n

.meas tran vdout1_13ck1780 FIND v(dout1_13) AT=1790.05n

.meas tran vdout1_14ck1780 FIND v(dout1_14) AT=1790.05n

.meas tran vdout1_15ck1780 FIND v(dout1_15) AT=1790.05n

.meas tran vdout1_16ck1780 FIND v(dout1_16) AT=1790.05n

.meas tran vdout1_17ck1780 FIND v(dout1_17) AT=1790.05n

.meas tran vdout1_18ck1780 FIND v(dout1_18) AT=1790.05n

.meas tran vdout1_19ck1780 FIND v(dout1_19) AT=1790.05n

.meas tran vdout1_0ck1790 FIND v(dout1_0) AT=1800.05n

.meas tran vdout1_1ck1790 FIND v(dout1_1) AT=1800.05n

.meas tran vdout1_2ck1790 FIND v(dout1_2) AT=1800.05n

.meas tran vdout1_3ck1790 FIND v(dout1_3) AT=1800.05n

.meas tran vdout1_4ck1790 FIND v(dout1_4) AT=1800.05n

.meas tran vdout1_5ck1790 FIND v(dout1_5) AT=1800.05n

.meas tran vdout1_6ck1790 FIND v(dout1_6) AT=1800.05n

.meas tran vdout1_7ck1790 FIND v(dout1_7) AT=1800.05n

.meas tran vdout1_8ck1790 FIND v(dout1_8) AT=1800.05n

.meas tran vdout1_9ck1790 FIND v(dout1_9) AT=1800.05n

.meas tran vdout1_10ck1790 FIND v(dout1_10) AT=1800.05n

.meas tran vdout1_11ck1790 FIND v(dout1_11) AT=1800.05n

.meas tran vdout1_12ck1790 FIND v(dout1_12) AT=1800.05n

.meas tran vdout1_13ck1790 FIND v(dout1_13) AT=1800.05n

.meas tran vdout1_14ck1790 FIND v(dout1_14) AT=1800.05n

.meas tran vdout1_15ck1790 FIND v(dout1_15) AT=1800.05n

.meas tran vdout1_16ck1790 FIND v(dout1_16) AT=1800.05n

.meas tran vdout1_17ck1790 FIND v(dout1_17) AT=1800.05n

.meas tran vdout1_18ck1790 FIND v(dout1_18) AT=1800.05n

.meas tran vdout1_19ck1790 FIND v(dout1_19) AT=1800.05n

.meas tran vdout1_0ck1800 FIND v(dout1_0) AT=1810.05n

.meas tran vdout1_1ck1800 FIND v(dout1_1) AT=1810.05n

.meas tran vdout1_2ck1800 FIND v(dout1_2) AT=1810.05n

.meas tran vdout1_3ck1800 FIND v(dout1_3) AT=1810.05n

.meas tran vdout1_4ck1800 FIND v(dout1_4) AT=1810.05n

.meas tran vdout1_5ck1800 FIND v(dout1_5) AT=1810.05n

.meas tran vdout1_6ck1800 FIND v(dout1_6) AT=1810.05n

.meas tran vdout1_7ck1800 FIND v(dout1_7) AT=1810.05n

.meas tran vdout1_8ck1800 FIND v(dout1_8) AT=1810.05n

.meas tran vdout1_9ck1800 FIND v(dout1_9) AT=1810.05n

.meas tran vdout1_10ck1800 FIND v(dout1_10) AT=1810.05n

.meas tran vdout1_11ck1800 FIND v(dout1_11) AT=1810.05n

.meas tran vdout1_12ck1800 FIND v(dout1_12) AT=1810.05n

.meas tran vdout1_13ck1800 FIND v(dout1_13) AT=1810.05n

.meas tran vdout1_14ck1800 FIND v(dout1_14) AT=1810.05n

.meas tran vdout1_15ck1800 FIND v(dout1_15) AT=1810.05n

.meas tran vdout1_16ck1800 FIND v(dout1_16) AT=1810.05n

.meas tran vdout1_17ck1800 FIND v(dout1_17) AT=1810.05n

.meas tran vdout1_18ck1800 FIND v(dout1_18) AT=1810.05n

.meas tran vdout1_19ck1800 FIND v(dout1_19) AT=1810.05n

.meas tran vdout1_0ck1810 FIND v(dout1_0) AT=1820.05n

.meas tran vdout1_1ck1810 FIND v(dout1_1) AT=1820.05n

.meas tran vdout1_2ck1810 FIND v(dout1_2) AT=1820.05n

.meas tran vdout1_3ck1810 FIND v(dout1_3) AT=1820.05n

.meas tran vdout1_4ck1810 FIND v(dout1_4) AT=1820.05n

.meas tran vdout1_5ck1810 FIND v(dout1_5) AT=1820.05n

.meas tran vdout1_6ck1810 FIND v(dout1_6) AT=1820.05n

.meas tran vdout1_7ck1810 FIND v(dout1_7) AT=1820.05n

.meas tran vdout1_8ck1810 FIND v(dout1_8) AT=1820.05n

.meas tran vdout1_9ck1810 FIND v(dout1_9) AT=1820.05n

.meas tran vdout1_10ck1810 FIND v(dout1_10) AT=1820.05n

.meas tran vdout1_11ck1810 FIND v(dout1_11) AT=1820.05n

.meas tran vdout1_12ck1810 FIND v(dout1_12) AT=1820.05n

.meas tran vdout1_13ck1810 FIND v(dout1_13) AT=1820.05n

.meas tran vdout1_14ck1810 FIND v(dout1_14) AT=1820.05n

.meas tran vdout1_15ck1810 FIND v(dout1_15) AT=1820.05n

.meas tran vdout1_16ck1810 FIND v(dout1_16) AT=1820.05n

.meas tran vdout1_17ck1810 FIND v(dout1_17) AT=1820.05n

.meas tran vdout1_18ck1810 FIND v(dout1_18) AT=1820.05n

.meas tran vdout1_19ck1810 FIND v(dout1_19) AT=1820.05n

.meas tran vdout1_0ck1820 FIND v(dout1_0) AT=1830.05n

.meas tran vdout1_1ck1820 FIND v(dout1_1) AT=1830.05n

.meas tran vdout1_2ck1820 FIND v(dout1_2) AT=1830.05n

.meas tran vdout1_3ck1820 FIND v(dout1_3) AT=1830.05n

.meas tran vdout1_4ck1820 FIND v(dout1_4) AT=1830.05n

.meas tran vdout1_5ck1820 FIND v(dout1_5) AT=1830.05n

.meas tran vdout1_6ck1820 FIND v(dout1_6) AT=1830.05n

.meas tran vdout1_7ck1820 FIND v(dout1_7) AT=1830.05n

.meas tran vdout1_8ck1820 FIND v(dout1_8) AT=1830.05n

.meas tran vdout1_9ck1820 FIND v(dout1_9) AT=1830.05n

.meas tran vdout1_10ck1820 FIND v(dout1_10) AT=1830.05n

.meas tran vdout1_11ck1820 FIND v(dout1_11) AT=1830.05n

.meas tran vdout1_12ck1820 FIND v(dout1_12) AT=1830.05n

.meas tran vdout1_13ck1820 FIND v(dout1_13) AT=1830.05n

.meas tran vdout1_14ck1820 FIND v(dout1_14) AT=1830.05n

.meas tran vdout1_15ck1820 FIND v(dout1_15) AT=1830.05n

.meas tran vdout1_16ck1820 FIND v(dout1_16) AT=1830.05n

.meas tran vdout1_17ck1820 FIND v(dout1_17) AT=1830.05n

.meas tran vdout1_18ck1820 FIND v(dout1_18) AT=1830.05n

.meas tran vdout1_19ck1820 FIND v(dout1_19) AT=1830.05n

.meas tran vdout1_0ck1910 FIND v(dout1_0) AT=1920.05n

.meas tran vdout1_1ck1910 FIND v(dout1_1) AT=1920.05n

.meas tran vdout1_2ck1910 FIND v(dout1_2) AT=1920.05n

.meas tran vdout1_3ck1910 FIND v(dout1_3) AT=1920.05n

.meas tran vdout1_4ck1910 FIND v(dout1_4) AT=1920.05n

.meas tran vdout1_5ck1910 FIND v(dout1_5) AT=1920.05n

.meas tran vdout1_6ck1910 FIND v(dout1_6) AT=1920.05n

.meas tran vdout1_7ck1910 FIND v(dout1_7) AT=1920.05n

.meas tran vdout1_8ck1910 FIND v(dout1_8) AT=1920.05n

.meas tran vdout1_9ck1910 FIND v(dout1_9) AT=1920.05n

.meas tran vdout1_10ck1910 FIND v(dout1_10) AT=1920.05n

.meas tran vdout1_11ck1910 FIND v(dout1_11) AT=1920.05n

.meas tran vdout1_12ck1910 FIND v(dout1_12) AT=1920.05n

.meas tran vdout1_13ck1910 FIND v(dout1_13) AT=1920.05n

.meas tran vdout1_14ck1910 FIND v(dout1_14) AT=1920.05n

.meas tran vdout1_15ck1910 FIND v(dout1_15) AT=1920.05n

.meas tran vdout1_16ck1910 FIND v(dout1_16) AT=1920.05n

.meas tran vdout1_17ck1910 FIND v(dout1_17) AT=1920.05n

.meas tran vdout1_18ck1910 FIND v(dout1_18) AT=1920.05n

.meas tran vdout1_19ck1910 FIND v(dout1_19) AT=1920.05n

.meas tran vdout1_0ck1980 FIND v(dout1_0) AT=1990.05n

.meas tran vdout1_1ck1980 FIND v(dout1_1) AT=1990.05n

.meas tran vdout1_2ck1980 FIND v(dout1_2) AT=1990.05n

.meas tran vdout1_3ck1980 FIND v(dout1_3) AT=1990.05n

.meas tran vdout1_4ck1980 FIND v(dout1_4) AT=1990.05n

.meas tran vdout1_5ck1980 FIND v(dout1_5) AT=1990.05n

.meas tran vdout1_6ck1980 FIND v(dout1_6) AT=1990.05n

.meas tran vdout1_7ck1980 FIND v(dout1_7) AT=1990.05n

.meas tran vdout1_8ck1980 FIND v(dout1_8) AT=1990.05n

.meas tran vdout1_9ck1980 FIND v(dout1_9) AT=1990.05n

.meas tran vdout1_10ck1980 FIND v(dout1_10) AT=1990.05n

.meas tran vdout1_11ck1980 FIND v(dout1_11) AT=1990.05n

.meas tran vdout1_12ck1980 FIND v(dout1_12) AT=1990.05n

.meas tran vdout1_13ck1980 FIND v(dout1_13) AT=1990.05n

.meas tran vdout1_14ck1980 FIND v(dout1_14) AT=1990.05n

.meas tran vdout1_15ck1980 FIND v(dout1_15) AT=1990.05n

.meas tran vdout1_16ck1980 FIND v(dout1_16) AT=1990.05n

.meas tran vdout1_17ck1980 FIND v(dout1_17) AT=1990.05n

.meas tran vdout1_18ck1980 FIND v(dout1_18) AT=1990.05n

.meas tran vdout1_19ck1980 FIND v(dout1_19) AT=1990.05n

.meas tran vdout1_0ck2020 FIND v(dout1_0) AT=2030.05n

.meas tran vdout1_1ck2020 FIND v(dout1_1) AT=2030.05n

.meas tran vdout1_2ck2020 FIND v(dout1_2) AT=2030.05n

.meas tran vdout1_3ck2020 FIND v(dout1_3) AT=2030.05n

.meas tran vdout1_4ck2020 FIND v(dout1_4) AT=2030.05n

.meas tran vdout1_5ck2020 FIND v(dout1_5) AT=2030.05n

.meas tran vdout1_6ck2020 FIND v(dout1_6) AT=2030.05n

.meas tran vdout1_7ck2020 FIND v(dout1_7) AT=2030.05n

.meas tran vdout1_8ck2020 FIND v(dout1_8) AT=2030.05n

.meas tran vdout1_9ck2020 FIND v(dout1_9) AT=2030.05n

.meas tran vdout1_10ck2020 FIND v(dout1_10) AT=2030.05n

.meas tran vdout1_11ck2020 FIND v(dout1_11) AT=2030.05n

.meas tran vdout1_12ck2020 FIND v(dout1_12) AT=2030.05n

.meas tran vdout1_13ck2020 FIND v(dout1_13) AT=2030.05n

.meas tran vdout1_14ck2020 FIND v(dout1_14) AT=2030.05n

.meas tran vdout1_15ck2020 FIND v(dout1_15) AT=2030.05n

.meas tran vdout1_16ck2020 FIND v(dout1_16) AT=2030.05n

.meas tran vdout1_17ck2020 FIND v(dout1_17) AT=2030.05n

.meas tran vdout1_18ck2020 FIND v(dout1_18) AT=2030.05n

.meas tran vdout1_19ck2020 FIND v(dout1_19) AT=2030.05n

.meas tran vdout1_0ck2030 FIND v(dout1_0) AT=2040.05n

.meas tran vdout1_1ck2030 FIND v(dout1_1) AT=2040.05n

.meas tran vdout1_2ck2030 FIND v(dout1_2) AT=2040.05n

.meas tran vdout1_3ck2030 FIND v(dout1_3) AT=2040.05n

.meas tran vdout1_4ck2030 FIND v(dout1_4) AT=2040.05n

.meas tran vdout1_5ck2030 FIND v(dout1_5) AT=2040.05n

.meas tran vdout1_6ck2030 FIND v(dout1_6) AT=2040.05n

.meas tran vdout1_7ck2030 FIND v(dout1_7) AT=2040.05n

.meas tran vdout1_8ck2030 FIND v(dout1_8) AT=2040.05n

.meas tran vdout1_9ck2030 FIND v(dout1_9) AT=2040.05n

.meas tran vdout1_10ck2030 FIND v(dout1_10) AT=2040.05n

.meas tran vdout1_11ck2030 FIND v(dout1_11) AT=2040.05n

.meas tran vdout1_12ck2030 FIND v(dout1_12) AT=2040.05n

.meas tran vdout1_13ck2030 FIND v(dout1_13) AT=2040.05n

.meas tran vdout1_14ck2030 FIND v(dout1_14) AT=2040.05n

.meas tran vdout1_15ck2030 FIND v(dout1_15) AT=2040.05n

.meas tran vdout1_16ck2030 FIND v(dout1_16) AT=2040.05n

.meas tran vdout1_17ck2030 FIND v(dout1_17) AT=2040.05n

.meas tran vdout1_18ck2030 FIND v(dout1_18) AT=2040.05n

.meas tran vdout1_19ck2030 FIND v(dout1_19) AT=2040.05n

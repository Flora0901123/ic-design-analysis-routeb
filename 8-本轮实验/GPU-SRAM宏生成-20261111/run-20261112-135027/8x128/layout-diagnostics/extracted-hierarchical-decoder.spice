.subckt routeb_new_1w1r_8x128_hierarchical_decoder addr_0 addr_1 addr_2 addr_3 addr_4
+ addr_5 addr_6 decode_0 decode_1 decode_2 decode_3 decode_4 decode_5 decode_6 decode_7
+ decode_8 decode_9 decode_10 decode_11 decode_12 decode_13 decode_14 decode_15 decode_16
+ decode_17 decode_18 decode_19 decode_20 decode_21 decode_22 decode_23 decode_24
+ decode_25 decode_26 decode_27 decode_28 decode_29 decode_30 decode_31 decode_32
+ decode_33 decode_34 decode_35 decode_36 decode_37 decode_38 decode_39 decode_40
+ decode_41 decode_42 decode_43 decode_44 decode_45 decode_46 decode_47 decode_48
+ decode_49 decode_50 decode_51 decode_52 decode_53 decode_54 decode_55 decode_56
+ decode_57 decode_58 decode_59 decode_60 decode_61 decode_62 decode_63 decode_64
+ decode_65 decode_66 decode_67 decode_68 decode_69 decode_70 decode_71 decode_72
+ decode_73 decode_74 decode_75 decode_76 decode_77 decode_78 decode_79 decode_80
+ decode_81 decode_82 decode_83 decode_84 decode_85 decode_86 decode_87 decode_88
+ decode_89 decode_90 decode_91 decode_92 decode_93 decode_94 decode_95 decode_96
+ decode_97 decode_98 decode_99 decode_100 decode_101 decode_102 decode_103 decode_104
+ decode_105 decode_106 decode_107 decode_108 decode_109 decode_110 decode_111 decode_112
+ decode_113 decode_114 decode_115 decode_116 decode_117 decode_118 decode_119 decode_120
+ decode_121 decode_122 decode_123 decode_124 decode_125 decode_126 decode_127 vdd_uq2
+ vdd_uq1 vdd vdd_uq8 vdd_uq16 vdd_uq6 vdd_uq9 vdd_uq7 vdd_uq13 vdd_uq19 gnd vdd_uq17
Xrouteb_new_1w1r_8x128_and3_dec_8 decode_119 vdd_uq17 vdd_uq19 gnd routeb_new_1w1r_8x128_and3_dec_9/C
+ routeb_new_1w1r_8x128_and3_dec_9/B routeb_new_1w1r_8x128_and3_dec_8/A routeb_new_1w1r_8x128_and3_dec
Xrouteb_new_1w1r_8x128_and3_dec_14 decode_113 vdd_uq17 vdd_uq19 gnd routeb_new_1w1r_8x128_and3_dec_9/C
+ routeb_new_1w1r_8x128_and3_dec_95/B routeb_new_1w1r_8x128_and3_dec_6/A routeb_new_1w1r_8x128_and3_dec
Xrouteb_new_1w1r_8x128_and3_dec_25 decode_102 vdd_uq17 vdd_uq19 gnd routeb_new_1w1r_8x128_and3_dec_31/C
+ routeb_new_1w1r_8x128_and3_dec_9/B routeb_new_1w1r_8x128_and3_dec_9/A routeb_new_1w1r_8x128_and3_dec
Xrouteb_new_1w1r_8x128_and3_dec_69 decode_58 vdd_uq17 vdd_uq19 gnd routeb_new_1w1r_8x128_and3_dec_79/C
+ routeb_new_1w1r_8x128_and3_dec_7/B routeb_new_1w1r_8x128_and3_dec_9/A routeb_new_1w1r_8x128_and3_dec
Xrouteb_new_1w1r_8x128_and3_dec_58 decode_69 vdd_uq17 vdd_uq19 gnd routeb_new_1w1r_8x128_and3_dec_63/C
+ routeb_new_1w1r_8x128_and3_dec_9/B routeb_new_1w1r_8x128_and3_dec_6/A routeb_new_1w1r_8x128_and3_dec
Xrouteb_new_1w1r_8x128_and3_dec_47 decode_80 vdd_uq17 vdd_uq19 gnd routeb_new_1w1r_8x128_and3_dec_47/C
+ routeb_new_1w1r_8x128_and3_dec_95/B routeb_new_1w1r_8x128_and3_dec_7/A routeb_new_1w1r_8x128_and3_dec
Xrouteb_new_1w1r_8x128_and3_dec_36 decode_91 vdd_uq17 vdd_uq19 gnd routeb_new_1w1r_8x128_and3_dec_47/C
+ routeb_new_1w1r_8x128_and3_dec_7/B routeb_new_1w1r_8x128_and3_dec_8/A routeb_new_1w1r_8x128_and3_dec
Xrouteb_new_1w1r_8x128_and3_dec_15 decode_112 vdd_uq17 vdd_uq19 gnd routeb_new_1w1r_8x128_and3_dec_9/C
+ routeb_new_1w1r_8x128_and3_dec_95/B routeb_new_1w1r_8x128_and3_dec_7/A routeb_new_1w1r_8x128_and3_dec
Xrouteb_new_1w1r_8x128_and3_dec_26 decode_101 vdd_uq17 vdd_uq19 gnd routeb_new_1w1r_8x128_and3_dec_31/C
+ routeb_new_1w1r_8x128_and3_dec_9/B routeb_new_1w1r_8x128_and3_dec_6/A routeb_new_1w1r_8x128_and3_dec
Xrouteb_new_1w1r_8x128_and3_dec_59 decode_68 vdd_uq17 vdd_uq19 gnd routeb_new_1w1r_8x128_and3_dec_63/C
+ routeb_new_1w1r_8x128_and3_dec_9/B routeb_new_1w1r_8x128_and3_dec_7/A routeb_new_1w1r_8x128_and3_dec
Xrouteb_new_1w1r_8x128_and3_dec_48 decode_79 vdd_uq17 vdd_uq19 gnd routeb_new_1w1r_8x128_and3_dec_63/C
+ routeb_new_1w1r_8x128_and3_dec_3/B routeb_new_1w1r_8x128_and3_dec_8/A routeb_new_1w1r_8x128_and3_dec
Xrouteb_new_1w1r_8x128_and3_dec_37 decode_90 vdd_uq17 vdd_uq19 gnd routeb_new_1w1r_8x128_and3_dec_47/C
+ routeb_new_1w1r_8x128_and3_dec_7/B routeb_new_1w1r_8x128_and3_dec_9/A routeb_new_1w1r_8x128_and3_dec
Xrouteb_new_1w1r_8x128_and3_dec_9 decode_118 vdd_uq17 vdd_uq19 gnd routeb_new_1w1r_8x128_and3_dec_9/C
+ routeb_new_1w1r_8x128_and3_dec_9/B routeb_new_1w1r_8x128_and3_dec_9/A routeb_new_1w1r_8x128_and3_dec
Xrouteb_new_1w1r_8x128_and3_dec_16 decode_111 vdd_uq17 vdd_uq19 gnd routeb_new_1w1r_8x128_and3_dec_31/C
+ routeb_new_1w1r_8x128_and3_dec_3/B routeb_new_1w1r_8x128_and3_dec_8/A routeb_new_1w1r_8x128_and3_dec
Xrouteb_new_1w1r_8x128_and3_dec_27 decode_100 vdd_uq17 vdd_uq19 gnd routeb_new_1w1r_8x128_and3_dec_31/C
+ routeb_new_1w1r_8x128_and3_dec_9/B routeb_new_1w1r_8x128_and3_dec_7/A routeb_new_1w1r_8x128_and3_dec
Xrouteb_new_1w1r_8x128_and3_dec_49 decode_78 vdd_uq17 vdd_uq19 gnd routeb_new_1w1r_8x128_and3_dec_63/C
+ routeb_new_1w1r_8x128_and3_dec_3/B routeb_new_1w1r_8x128_and3_dec_9/A routeb_new_1w1r_8x128_and3_dec
Xrouteb_new_1w1r_8x128_and3_dec_38 decode_89 vdd_uq17 vdd_uq19 gnd routeb_new_1w1r_8x128_and3_dec_47/C
+ routeb_new_1w1r_8x128_and3_dec_7/B routeb_new_1w1r_8x128_and3_dec_6/A routeb_new_1w1r_8x128_and3_dec
Xrouteb_new_1w1r_8x128_and3_dec_17 decode_110 vdd_uq17 vdd_uq19 gnd routeb_new_1w1r_8x128_and3_dec_31/C
+ routeb_new_1w1r_8x128_and3_dec_3/B routeb_new_1w1r_8x128_and3_dec_9/A routeb_new_1w1r_8x128_and3_dec
Xrouteb_new_1w1r_8x128_and3_dec_28 decode_99 vdd_uq17 vdd_uq19 gnd routeb_new_1w1r_8x128_and3_dec_31/C
+ routeb_new_1w1r_8x128_and3_dec_95/B routeb_new_1w1r_8x128_and3_dec_8/A routeb_new_1w1r_8x128_and3_dec
Xrouteb_new_1w1r_8x128_and3_dec_39 decode_88 vdd_uq17 vdd_uq19 gnd routeb_new_1w1r_8x128_and3_dec_47/C
+ routeb_new_1w1r_8x128_and3_dec_7/B routeb_new_1w1r_8x128_and3_dec_7/A routeb_new_1w1r_8x128_and3_dec
Xrouteb_new_1w1r_8x128_and3_dec_18 decode_109 vdd_uq17 vdd_uq19 gnd routeb_new_1w1r_8x128_and3_dec_31/C
+ routeb_new_1w1r_8x128_and3_dec_3/B routeb_new_1w1r_8x128_and3_dec_6/A routeb_new_1w1r_8x128_and3_dec
Xrouteb_new_1w1r_8x128_and3_dec_29 decode_98 vdd_uq17 vdd_uq19 gnd routeb_new_1w1r_8x128_and3_dec_31/C
+ routeb_new_1w1r_8x128_and3_dec_95/B routeb_new_1w1r_8x128_and3_dec_9/A routeb_new_1w1r_8x128_and3_dec
Xrouteb_new_1w1r_8x128_and3_dec_19 decode_108 vdd_uq17 vdd_uq19 gnd routeb_new_1w1r_8x128_and3_dec_31/C
+ routeb_new_1w1r_8x128_and3_dec_3/B routeb_new_1w1r_8x128_and3_dec_7/A routeb_new_1w1r_8x128_and3_dec
Xrouteb_new_1w1r_8x128_and3_dec_120 decode_7 vdd_uq17 vdd_uq19 gnd routeb_new_1w1r_8x128_and3_dec_127/C
+ routeb_new_1w1r_8x128_and3_dec_9/B routeb_new_1w1r_8x128_and3_dec_8/A routeb_new_1w1r_8x128_and3_dec
Xrouteb_new_1w1r_8x128_hierarchical_predecode2x4_0 addr_2 addr_3 routeb_new_1w1r_8x128_and3_dec_95/B
+ routeb_new_1w1r_8x128_and3_dec_9/B routeb_new_1w1r_8x128_and3_dec_7/B routeb_new_1w1r_8x128_and3_dec_3/B
+ vdd_uq8 vdd_uq7 vdd_uq6 gnd routeb_new_1w1r_8x128_hierarchical_predecode2x4
Xrouteb_new_1w1r_8x128_and3_dec_121 decode_6 vdd_uq17 vdd_uq19 gnd routeb_new_1w1r_8x128_and3_dec_127/C
+ routeb_new_1w1r_8x128_and3_dec_9/B routeb_new_1w1r_8x128_and3_dec_9/A routeb_new_1w1r_8x128_and3_dec
Xrouteb_new_1w1r_8x128_and3_dec_110 decode_17 vdd_uq17 vdd_uq19 gnd routeb_new_1w1r_8x128_and3_dec_99/C
+ routeb_new_1w1r_8x128_and3_dec_95/B routeb_new_1w1r_8x128_and3_dec_6/A routeb_new_1w1r_8x128_and3_dec
Xrouteb_new_1w1r_8x128_hierarchical_predecode2x4_1 addr_0 addr_1 routeb_new_1w1r_8x128_and3_dec_7/A
+ routeb_new_1w1r_8x128_and3_dec_6/A routeb_new_1w1r_8x128_and3_dec_9/A routeb_new_1w1r_8x128_and3_dec_8/A
+ vdd vdd_uq2 vdd_uq1 gnd routeb_new_1w1r_8x128_hierarchical_predecode2x4
Xrouteb_new_1w1r_8x128_and3_dec_122 decode_5 vdd_uq17 vdd_uq19 gnd routeb_new_1w1r_8x128_and3_dec_127/C
+ routeb_new_1w1r_8x128_and3_dec_9/B routeb_new_1w1r_8x128_and3_dec_6/A routeb_new_1w1r_8x128_and3_dec
Xrouteb_new_1w1r_8x128_and3_dec_111 decode_16 vdd_uq17 vdd_uq19 gnd routeb_new_1w1r_8x128_and3_dec_99/C
+ routeb_new_1w1r_8x128_and3_dec_95/B routeb_new_1w1r_8x128_and3_dec_7/A routeb_new_1w1r_8x128_and3_dec
Xrouteb_new_1w1r_8x128_and3_dec_100 decode_27 vdd_uq17 vdd_uq19 gnd routeb_new_1w1r_8x128_and3_dec_99/C
+ routeb_new_1w1r_8x128_and3_dec_7/B routeb_new_1w1r_8x128_and3_dec_8/A routeb_new_1w1r_8x128_and3_dec
Xrouteb_new_1w1r_8x128_and3_dec_123 decode_4 vdd_uq17 vdd_uq19 gnd routeb_new_1w1r_8x128_and3_dec_127/C
+ routeb_new_1w1r_8x128_and3_dec_9/B routeb_new_1w1r_8x128_and3_dec_7/A routeb_new_1w1r_8x128_and3_dec
Xrouteb_new_1w1r_8x128_and3_dec_112 decode_15 vdd_uq17 vdd_uq19 gnd routeb_new_1w1r_8x128_and3_dec_127/C
+ routeb_new_1w1r_8x128_and3_dec_3/B routeb_new_1w1r_8x128_and3_dec_8/A routeb_new_1w1r_8x128_and3_dec
Xrouteb_new_1w1r_8x128_and3_dec_101 decode_26 vdd_uq17 vdd_uq19 gnd routeb_new_1w1r_8x128_and3_dec_99/C
+ routeb_new_1w1r_8x128_and3_dec_7/B routeb_new_1w1r_8x128_and3_dec_9/A routeb_new_1w1r_8x128_and3_dec
Xrouteb_new_1w1r_8x128_and3_dec_124 decode_3 vdd_uq17 vdd_uq19 gnd routeb_new_1w1r_8x128_and3_dec_127/C
+ routeb_new_1w1r_8x128_and3_dec_95/B routeb_new_1w1r_8x128_and3_dec_8/A routeb_new_1w1r_8x128_and3_dec
Xrouteb_new_1w1r_8x128_and3_dec_113 decode_14 vdd_uq17 vdd_uq19 gnd routeb_new_1w1r_8x128_and3_dec_127/C
+ routeb_new_1w1r_8x128_and3_dec_3/B routeb_new_1w1r_8x128_and3_dec_9/A routeb_new_1w1r_8x128_and3_dec
Xrouteb_new_1w1r_8x128_and3_dec_102 decode_25 vdd_uq17 vdd_uq19 gnd routeb_new_1w1r_8x128_and3_dec_99/C
+ routeb_new_1w1r_8x128_and3_dec_7/B routeb_new_1w1r_8x128_and3_dec_6/A routeb_new_1w1r_8x128_and3_dec
Xrouteb_new_1w1r_8x128_and3_dec_125 decode_2 vdd_uq17 vdd_uq19 gnd routeb_new_1w1r_8x128_and3_dec_127/C
+ routeb_new_1w1r_8x128_and3_dec_95/B routeb_new_1w1r_8x128_and3_dec_9/A routeb_new_1w1r_8x128_and3_dec
Xrouteb_new_1w1r_8x128_and3_dec_114 decode_13 vdd_uq17 vdd_uq19 gnd routeb_new_1w1r_8x128_and3_dec_127/C
+ routeb_new_1w1r_8x128_and3_dec_3/B routeb_new_1w1r_8x128_and3_dec_6/A routeb_new_1w1r_8x128_and3_dec
Xrouteb_new_1w1r_8x128_and3_dec_103 decode_24 vdd_uq17 vdd_uq19 gnd routeb_new_1w1r_8x128_and3_dec_99/C
+ routeb_new_1w1r_8x128_and3_dec_7/B routeb_new_1w1r_8x128_and3_dec_7/A routeb_new_1w1r_8x128_and3_dec
Xrouteb_new_1w1r_8x128_and3_dec_126 decode_1 vdd_uq17 vdd_uq19 gnd routeb_new_1w1r_8x128_and3_dec_127/C
+ routeb_new_1w1r_8x128_and3_dec_95/B routeb_new_1w1r_8x128_and3_dec_6/A routeb_new_1w1r_8x128_and3_dec
Xrouteb_new_1w1r_8x128_and3_dec_115 decode_12 vdd_uq17 vdd_uq19 gnd routeb_new_1w1r_8x128_and3_dec_127/C
+ routeb_new_1w1r_8x128_and3_dec_3/B routeb_new_1w1r_8x128_and3_dec_7/A routeb_new_1w1r_8x128_and3_dec
Xrouteb_new_1w1r_8x128_and3_dec_104 decode_23 vdd_uq17 vdd_uq19 gnd routeb_new_1w1r_8x128_and3_dec_99/C
+ routeb_new_1w1r_8x128_and3_dec_9/B routeb_new_1w1r_8x128_and3_dec_8/A routeb_new_1w1r_8x128_and3_dec
Xrouteb_new_1w1r_8x128_and3_dec_127 decode_0 vdd_uq17 vdd_uq19 gnd routeb_new_1w1r_8x128_and3_dec_127/C
+ routeb_new_1w1r_8x128_and3_dec_95/B routeb_new_1w1r_8x128_and3_dec_7/A routeb_new_1w1r_8x128_and3_dec
Xrouteb_new_1w1r_8x128_and3_dec_116 decode_11 vdd_uq17 vdd_uq19 gnd routeb_new_1w1r_8x128_and3_dec_127/C
+ routeb_new_1w1r_8x128_and3_dec_7/B routeb_new_1w1r_8x128_and3_dec_8/A routeb_new_1w1r_8x128_and3_dec
Xrouteb_new_1w1r_8x128_and3_dec_105 decode_22 vdd_uq17 vdd_uq19 gnd routeb_new_1w1r_8x128_and3_dec_99/C
+ routeb_new_1w1r_8x128_and3_dec_9/B routeb_new_1w1r_8x128_and3_dec_9/A routeb_new_1w1r_8x128_and3_dec
Xrouteb_new_1w1r_8x128_and3_dec_117 decode_10 vdd_uq17 vdd_uq19 gnd routeb_new_1w1r_8x128_and3_dec_127/C
+ routeb_new_1w1r_8x128_and3_dec_7/B routeb_new_1w1r_8x128_and3_dec_9/A routeb_new_1w1r_8x128_and3_dec
Xrouteb_new_1w1r_8x128_and3_dec_106 decode_21 vdd_uq17 vdd_uq19 gnd routeb_new_1w1r_8x128_and3_dec_99/C
+ routeb_new_1w1r_8x128_and3_dec_9/B routeb_new_1w1r_8x128_and3_dec_6/A routeb_new_1w1r_8x128_and3_dec
Xrouteb_new_1w1r_8x128_and3_dec_118 decode_9 vdd_uq17 vdd_uq19 gnd routeb_new_1w1r_8x128_and3_dec_127/C
+ routeb_new_1w1r_8x128_and3_dec_7/B routeb_new_1w1r_8x128_and3_dec_6/A routeb_new_1w1r_8x128_and3_dec
Xrouteb_new_1w1r_8x128_and3_dec_107 decode_20 vdd_uq17 vdd_uq19 gnd routeb_new_1w1r_8x128_and3_dec_99/C
+ routeb_new_1w1r_8x128_and3_dec_9/B routeb_new_1w1r_8x128_and3_dec_7/A routeb_new_1w1r_8x128_and3_dec
Xrouteb_new_1w1r_8x128_and3_dec_119 decode_8 vdd_uq17 vdd_uq19 gnd routeb_new_1w1r_8x128_and3_dec_127/C
+ routeb_new_1w1r_8x128_and3_dec_7/B routeb_new_1w1r_8x128_and3_dec_7/A routeb_new_1w1r_8x128_and3_dec
Xrouteb_new_1w1r_8x128_and3_dec_108 decode_19 vdd_uq17 vdd_uq19 gnd routeb_new_1w1r_8x128_and3_dec_99/C
+ routeb_new_1w1r_8x128_and3_dec_95/B routeb_new_1w1r_8x128_and3_dec_8/A routeb_new_1w1r_8x128_and3_dec
Xrouteb_new_1w1r_8x128_and3_dec_109 decode_18 vdd_uq17 vdd_uq19 gnd routeb_new_1w1r_8x128_and3_dec_99/C
+ routeb_new_1w1r_8x128_and3_dec_95/B routeb_new_1w1r_8x128_and3_dec_9/A routeb_new_1w1r_8x128_and3_dec
Xrouteb_new_1w1r_8x128_and3_dec_90 decode_37 vdd_uq17 vdd_uq19 gnd routeb_new_1w1r_8x128_and3_dec_95/C
+ routeb_new_1w1r_8x128_and3_dec_9/B routeb_new_1w1r_8x128_and3_dec_6/A routeb_new_1w1r_8x128_and3_dec
Xrouteb_new_1w1r_8x128_and3_dec_91 decode_36 vdd_uq17 vdd_uq19 gnd routeb_new_1w1r_8x128_and3_dec_95/C
+ routeb_new_1w1r_8x128_and3_dec_9/B routeb_new_1w1r_8x128_and3_dec_7/A routeb_new_1w1r_8x128_and3_dec
Xrouteb_new_1w1r_8x128_and3_dec_80 decode_47 vdd_uq17 vdd_uq19 gnd routeb_new_1w1r_8x128_and3_dec_95/C
+ routeb_new_1w1r_8x128_and3_dec_3/B routeb_new_1w1r_8x128_and3_dec_8/A routeb_new_1w1r_8x128_and3_dec
Xrouteb_new_1w1r_8x128_and3_dec_92 decode_35 vdd_uq17 vdd_uq19 gnd routeb_new_1w1r_8x128_and3_dec_95/C
+ routeb_new_1w1r_8x128_and3_dec_95/B routeb_new_1w1r_8x128_and3_dec_8/A routeb_new_1w1r_8x128_and3_dec
Xrouteb_new_1w1r_8x128_and3_dec_81 decode_46 vdd_uq17 vdd_uq19 gnd routeb_new_1w1r_8x128_and3_dec_95/C
+ routeb_new_1w1r_8x128_and3_dec_3/B routeb_new_1w1r_8x128_and3_dec_9/A routeb_new_1w1r_8x128_and3_dec
Xrouteb_new_1w1r_8x128_and3_dec_70 decode_57 vdd_uq17 vdd_uq19 gnd routeb_new_1w1r_8x128_and3_dec_79/C
+ routeb_new_1w1r_8x128_and3_dec_7/B routeb_new_1w1r_8x128_and3_dec_6/A routeb_new_1w1r_8x128_and3_dec
Xrouteb_new_1w1r_8x128_and3_dec_93 decode_34 vdd_uq17 vdd_uq19 gnd routeb_new_1w1r_8x128_and3_dec_95/C
+ routeb_new_1w1r_8x128_and3_dec_95/B routeb_new_1w1r_8x128_and3_dec_9/A routeb_new_1w1r_8x128_and3_dec
Xrouteb_new_1w1r_8x128_and3_dec_82 decode_45 vdd_uq17 vdd_uq19 gnd routeb_new_1w1r_8x128_and3_dec_95/C
+ routeb_new_1w1r_8x128_and3_dec_3/B routeb_new_1w1r_8x128_and3_dec_6/A routeb_new_1w1r_8x128_and3_dec
Xrouteb_new_1w1r_8x128_and3_dec_71 decode_56 vdd_uq17 vdd_uq19 gnd routeb_new_1w1r_8x128_and3_dec_79/C
+ routeb_new_1w1r_8x128_and3_dec_7/B routeb_new_1w1r_8x128_and3_dec_7/A routeb_new_1w1r_8x128_and3_dec
Xrouteb_new_1w1r_8x128_and3_dec_60 decode_67 vdd_uq17 vdd_uq19 gnd routeb_new_1w1r_8x128_and3_dec_63/C
+ routeb_new_1w1r_8x128_and3_dec_95/B routeb_new_1w1r_8x128_and3_dec_8/A routeb_new_1w1r_8x128_and3_dec
Xrouteb_new_1w1r_8x128_and3_dec_94 decode_33 vdd_uq17 vdd_uq19 gnd routeb_new_1w1r_8x128_and3_dec_95/C
+ routeb_new_1w1r_8x128_and3_dec_95/B routeb_new_1w1r_8x128_and3_dec_6/A routeb_new_1w1r_8x128_and3_dec
Xrouteb_new_1w1r_8x128_and3_dec_83 decode_44 vdd_uq17 vdd_uq19 gnd routeb_new_1w1r_8x128_and3_dec_95/C
+ routeb_new_1w1r_8x128_and3_dec_3/B routeb_new_1w1r_8x128_and3_dec_7/A routeb_new_1w1r_8x128_and3_dec
Xrouteb_new_1w1r_8x128_and3_dec_72 decode_55 vdd_uq17 vdd_uq19 gnd routeb_new_1w1r_8x128_and3_dec_79/C
+ routeb_new_1w1r_8x128_and3_dec_9/B routeb_new_1w1r_8x128_and3_dec_8/A routeb_new_1w1r_8x128_and3_dec
Xrouteb_new_1w1r_8x128_and3_dec_61 decode_66 vdd_uq17 vdd_uq19 gnd routeb_new_1w1r_8x128_and3_dec_63/C
+ routeb_new_1w1r_8x128_and3_dec_95/B routeb_new_1w1r_8x128_and3_dec_9/A routeb_new_1w1r_8x128_and3_dec
Xrouteb_new_1w1r_8x128_and3_dec_50 decode_77 vdd_uq17 vdd_uq19 gnd routeb_new_1w1r_8x128_and3_dec_63/C
+ routeb_new_1w1r_8x128_and3_dec_3/B routeb_new_1w1r_8x128_and3_dec_6/A routeb_new_1w1r_8x128_and3_dec
Xrouteb_new_1w1r_8x128_and3_dec_0 decode_127 vdd_uq17 vdd_uq19 gnd routeb_new_1w1r_8x128_and3_dec_9/C
+ routeb_new_1w1r_8x128_and3_dec_3/B routeb_new_1w1r_8x128_and3_dec_8/A routeb_new_1w1r_8x128_and3_dec
Xrouteb_new_1w1r_8x128_hierarchical_predecode3x8_0 addr_4 addr_5 addr_6 routeb_new_1w1r_8x128_and3_dec_127/C
+ routeb_new_1w1r_8x128_and3_dec_99/C routeb_new_1w1r_8x128_and3_dec_95/C routeb_new_1w1r_8x128_and3_dec_79/C
+ routeb_new_1w1r_8x128_and3_dec_63/C routeb_new_1w1r_8x128_and3_dec_47/C routeb_new_1w1r_8x128_and3_dec_31/C
+ routeb_new_1w1r_8x128_and3_dec_9/C vdd_uq13 gnd vdd_uq16 vdd_uq9 routeb_new_1w1r_8x128_hierarchical_predecode3x8
Xrouteb_new_1w1r_8x128_and3_dec_1 decode_126 vdd_uq17 vdd_uq19 gnd routeb_new_1w1r_8x128_and3_dec_9/C
+ routeb_new_1w1r_8x128_and3_dec_3/B routeb_new_1w1r_8x128_and3_dec_9/A routeb_new_1w1r_8x128_and3_dec
Xrouteb_new_1w1r_8x128_and3_dec_95 decode_32 vdd_uq17 vdd_uq19 gnd routeb_new_1w1r_8x128_and3_dec_95/C
+ routeb_new_1w1r_8x128_and3_dec_95/B routeb_new_1w1r_8x128_and3_dec_7/A routeb_new_1w1r_8x128_and3_dec
Xrouteb_new_1w1r_8x128_and3_dec_84 decode_43 vdd_uq17 vdd_uq19 gnd routeb_new_1w1r_8x128_and3_dec_95/C
+ routeb_new_1w1r_8x128_and3_dec_7/B routeb_new_1w1r_8x128_and3_dec_8/A routeb_new_1w1r_8x128_and3_dec
Xrouteb_new_1w1r_8x128_and3_dec_73 decode_54 vdd_uq17 vdd_uq19 gnd routeb_new_1w1r_8x128_and3_dec_79/C
+ routeb_new_1w1r_8x128_and3_dec_9/B routeb_new_1w1r_8x128_and3_dec_9/A routeb_new_1w1r_8x128_and3_dec
Xrouteb_new_1w1r_8x128_and3_dec_62 decode_65 vdd_uq17 vdd_uq19 gnd routeb_new_1w1r_8x128_and3_dec_63/C
+ routeb_new_1w1r_8x128_and3_dec_95/B routeb_new_1w1r_8x128_and3_dec_6/A routeb_new_1w1r_8x128_and3_dec
Xrouteb_new_1w1r_8x128_and3_dec_51 decode_76 vdd_uq17 vdd_uq19 gnd routeb_new_1w1r_8x128_and3_dec_63/C
+ routeb_new_1w1r_8x128_and3_dec_3/B routeb_new_1w1r_8x128_and3_dec_7/A routeb_new_1w1r_8x128_and3_dec
Xrouteb_new_1w1r_8x128_and3_dec_40 decode_87 vdd_uq17 vdd_uq19 gnd routeb_new_1w1r_8x128_and3_dec_47/C
+ routeb_new_1w1r_8x128_and3_dec_9/B routeb_new_1w1r_8x128_and3_dec_8/A routeb_new_1w1r_8x128_and3_dec
Xrouteb_new_1w1r_8x128_and3_dec_2 decode_125 vdd_uq17 vdd_uq19 gnd routeb_new_1w1r_8x128_and3_dec_9/C
+ routeb_new_1w1r_8x128_and3_dec_3/B routeb_new_1w1r_8x128_and3_dec_6/A routeb_new_1w1r_8x128_and3_dec
Xrouteb_new_1w1r_8x128_and3_dec_30 decode_97 vdd_uq17 vdd_uq19 gnd routeb_new_1w1r_8x128_and3_dec_31/C
+ routeb_new_1w1r_8x128_and3_dec_95/B routeb_new_1w1r_8x128_and3_dec_6/A routeb_new_1w1r_8x128_and3_dec
Xrouteb_new_1w1r_8x128_and3_dec_96 decode_31 vdd_uq17 vdd_uq19 gnd routeb_new_1w1r_8x128_and3_dec_99/C
+ routeb_new_1w1r_8x128_and3_dec_3/B routeb_new_1w1r_8x128_and3_dec_8/A routeb_new_1w1r_8x128_and3_dec
Xrouteb_new_1w1r_8x128_and3_dec_85 decode_42 vdd_uq17 vdd_uq19 gnd routeb_new_1w1r_8x128_and3_dec_95/C
+ routeb_new_1w1r_8x128_and3_dec_7/B routeb_new_1w1r_8x128_and3_dec_9/A routeb_new_1w1r_8x128_and3_dec
Xrouteb_new_1w1r_8x128_and3_dec_74 decode_53 vdd_uq17 vdd_uq19 gnd routeb_new_1w1r_8x128_and3_dec_79/C
+ routeb_new_1w1r_8x128_and3_dec_9/B routeb_new_1w1r_8x128_and3_dec_6/A routeb_new_1w1r_8x128_and3_dec
Xrouteb_new_1w1r_8x128_and3_dec_63 decode_64 vdd_uq17 vdd_uq19 gnd routeb_new_1w1r_8x128_and3_dec_63/C
+ routeb_new_1w1r_8x128_and3_dec_95/B routeb_new_1w1r_8x128_and3_dec_7/A routeb_new_1w1r_8x128_and3_dec
Xrouteb_new_1w1r_8x128_and3_dec_52 decode_75 vdd_uq17 vdd_uq19 gnd routeb_new_1w1r_8x128_and3_dec_63/C
+ routeb_new_1w1r_8x128_and3_dec_7/B routeb_new_1w1r_8x128_and3_dec_8/A routeb_new_1w1r_8x128_and3_dec
Xrouteb_new_1w1r_8x128_and3_dec_41 decode_86 vdd_uq17 vdd_uq19 gnd routeb_new_1w1r_8x128_and3_dec_47/C
+ routeb_new_1w1r_8x128_and3_dec_9/B routeb_new_1w1r_8x128_and3_dec_9/A routeb_new_1w1r_8x128_and3_dec
Xrouteb_new_1w1r_8x128_and3_dec_3 decode_124 vdd_uq17 vdd_uq19 gnd routeb_new_1w1r_8x128_and3_dec_9/C
+ routeb_new_1w1r_8x128_and3_dec_3/B routeb_new_1w1r_8x128_and3_dec_7/A routeb_new_1w1r_8x128_and3_dec
Xrouteb_new_1w1r_8x128_and3_dec_20 decode_107 vdd_uq17 vdd_uq19 gnd routeb_new_1w1r_8x128_and3_dec_31/C
+ routeb_new_1w1r_8x128_and3_dec_7/B routeb_new_1w1r_8x128_and3_dec_8/A routeb_new_1w1r_8x128_and3_dec
Xrouteb_new_1w1r_8x128_and3_dec_31 decode_96 vdd_uq17 vdd_uq19 gnd routeb_new_1w1r_8x128_and3_dec_31/C
+ routeb_new_1w1r_8x128_and3_dec_95/B routeb_new_1w1r_8x128_and3_dec_7/A routeb_new_1w1r_8x128_and3_dec
Xrouteb_new_1w1r_8x128_and3_dec_97 decode_30 vdd_uq17 vdd_uq19 gnd routeb_new_1w1r_8x128_and3_dec_99/C
+ routeb_new_1w1r_8x128_and3_dec_3/B routeb_new_1w1r_8x128_and3_dec_9/A routeb_new_1w1r_8x128_and3_dec
Xrouteb_new_1w1r_8x128_and3_dec_86 decode_41 vdd_uq17 vdd_uq19 gnd routeb_new_1w1r_8x128_and3_dec_95/C
+ routeb_new_1w1r_8x128_and3_dec_7/B routeb_new_1w1r_8x128_and3_dec_6/A routeb_new_1w1r_8x128_and3_dec
Xrouteb_new_1w1r_8x128_and3_dec_75 decode_52 vdd_uq17 vdd_uq19 gnd routeb_new_1w1r_8x128_and3_dec_79/C
+ routeb_new_1w1r_8x128_and3_dec_9/B routeb_new_1w1r_8x128_and3_dec_7/A routeb_new_1w1r_8x128_and3_dec
Xrouteb_new_1w1r_8x128_and3_dec_64 decode_63 vdd_uq17 vdd_uq19 gnd routeb_new_1w1r_8x128_and3_dec_79/C
+ routeb_new_1w1r_8x128_and3_dec_3/B routeb_new_1w1r_8x128_and3_dec_8/A routeb_new_1w1r_8x128_and3_dec
Xrouteb_new_1w1r_8x128_and3_dec_53 decode_74 vdd_uq17 vdd_uq19 gnd routeb_new_1w1r_8x128_and3_dec_63/C
+ routeb_new_1w1r_8x128_and3_dec_7/B routeb_new_1w1r_8x128_and3_dec_9/A routeb_new_1w1r_8x128_and3_dec
Xrouteb_new_1w1r_8x128_and3_dec_42 decode_85 vdd_uq17 vdd_uq19 gnd routeb_new_1w1r_8x128_and3_dec_47/C
+ routeb_new_1w1r_8x128_and3_dec_9/B routeb_new_1w1r_8x128_and3_dec_6/A routeb_new_1w1r_8x128_and3_dec
Xrouteb_new_1w1r_8x128_and3_dec_4 decode_123 vdd_uq17 vdd_uq19 gnd routeb_new_1w1r_8x128_and3_dec_9/C
+ routeb_new_1w1r_8x128_and3_dec_7/B routeb_new_1w1r_8x128_and3_dec_8/A routeb_new_1w1r_8x128_and3_dec
Xrouteb_new_1w1r_8x128_and3_dec_10 decode_117 vdd_uq17 vdd_uq19 gnd routeb_new_1w1r_8x128_and3_dec_9/C
+ routeb_new_1w1r_8x128_and3_dec_9/B routeb_new_1w1r_8x128_and3_dec_6/A routeb_new_1w1r_8x128_and3_dec
Xrouteb_new_1w1r_8x128_and3_dec_21 decode_106 vdd_uq17 vdd_uq19 gnd routeb_new_1w1r_8x128_and3_dec_31/C
+ routeb_new_1w1r_8x128_and3_dec_7/B routeb_new_1w1r_8x128_and3_dec_9/A routeb_new_1w1r_8x128_and3_dec
Xrouteb_new_1w1r_8x128_and3_dec_32 decode_95 vdd_uq17 vdd_uq19 gnd routeb_new_1w1r_8x128_and3_dec_47/C
+ routeb_new_1w1r_8x128_and3_dec_3/B routeb_new_1w1r_8x128_and3_dec_8/A routeb_new_1w1r_8x128_and3_dec
Xrouteb_new_1w1r_8x128_and3_dec_98 decode_29 vdd_uq17 vdd_uq19 gnd routeb_new_1w1r_8x128_and3_dec_99/C
+ routeb_new_1w1r_8x128_and3_dec_3/B routeb_new_1w1r_8x128_and3_dec_6/A routeb_new_1w1r_8x128_and3_dec
Xrouteb_new_1w1r_8x128_and3_dec_87 decode_40 vdd_uq17 vdd_uq19 gnd routeb_new_1w1r_8x128_and3_dec_95/C
+ routeb_new_1w1r_8x128_and3_dec_7/B routeb_new_1w1r_8x128_and3_dec_7/A routeb_new_1w1r_8x128_and3_dec
Xrouteb_new_1w1r_8x128_and3_dec_76 decode_51 vdd_uq17 vdd_uq19 gnd routeb_new_1w1r_8x128_and3_dec_79/C
+ routeb_new_1w1r_8x128_and3_dec_95/B routeb_new_1w1r_8x128_and3_dec_8/A routeb_new_1w1r_8x128_and3_dec
Xrouteb_new_1w1r_8x128_and3_dec_65 decode_62 vdd_uq17 vdd_uq19 gnd routeb_new_1w1r_8x128_and3_dec_79/C
+ routeb_new_1w1r_8x128_and3_dec_3/B routeb_new_1w1r_8x128_and3_dec_9/A routeb_new_1w1r_8x128_and3_dec
Xrouteb_new_1w1r_8x128_and3_dec_54 decode_73 vdd_uq17 vdd_uq19 gnd routeb_new_1w1r_8x128_and3_dec_63/C
+ routeb_new_1w1r_8x128_and3_dec_7/B routeb_new_1w1r_8x128_and3_dec_6/A routeb_new_1w1r_8x128_and3_dec
Xrouteb_new_1w1r_8x128_and3_dec_43 decode_84 vdd_uq17 vdd_uq19 gnd routeb_new_1w1r_8x128_and3_dec_47/C
+ routeb_new_1w1r_8x128_and3_dec_9/B routeb_new_1w1r_8x128_and3_dec_7/A routeb_new_1w1r_8x128_and3_dec
Xrouteb_new_1w1r_8x128_and3_dec_5 decode_122 vdd_uq17 vdd_uq19 gnd routeb_new_1w1r_8x128_and3_dec_9/C
+ routeb_new_1w1r_8x128_and3_dec_7/B routeb_new_1w1r_8x128_and3_dec_9/A routeb_new_1w1r_8x128_and3_dec
Xrouteb_new_1w1r_8x128_and3_dec_11 decode_116 vdd_uq17 vdd_uq19 gnd routeb_new_1w1r_8x128_and3_dec_9/C
+ routeb_new_1w1r_8x128_and3_dec_9/B routeb_new_1w1r_8x128_and3_dec_7/A routeb_new_1w1r_8x128_and3_dec
Xrouteb_new_1w1r_8x128_and3_dec_22 decode_105 vdd_uq17 vdd_uq19 gnd routeb_new_1w1r_8x128_and3_dec_31/C
+ routeb_new_1w1r_8x128_and3_dec_7/B routeb_new_1w1r_8x128_and3_dec_6/A routeb_new_1w1r_8x128_and3_dec
Xrouteb_new_1w1r_8x128_and3_dec_33 decode_94 vdd_uq17 vdd_uq19 gnd routeb_new_1w1r_8x128_and3_dec_47/C
+ routeb_new_1w1r_8x128_and3_dec_3/B routeb_new_1w1r_8x128_and3_dec_9/A routeb_new_1w1r_8x128_and3_dec
Xrouteb_new_1w1r_8x128_and3_dec_99 decode_28 vdd_uq17 vdd_uq19 gnd routeb_new_1w1r_8x128_and3_dec_99/C
+ routeb_new_1w1r_8x128_and3_dec_3/B routeb_new_1w1r_8x128_and3_dec_7/A routeb_new_1w1r_8x128_and3_dec
Xrouteb_new_1w1r_8x128_and3_dec_88 decode_39 vdd_uq17 vdd_uq19 gnd routeb_new_1w1r_8x128_and3_dec_95/C
+ routeb_new_1w1r_8x128_and3_dec_9/B routeb_new_1w1r_8x128_and3_dec_8/A routeb_new_1w1r_8x128_and3_dec
Xrouteb_new_1w1r_8x128_and3_dec_77 decode_50 vdd_uq17 vdd_uq19 gnd routeb_new_1w1r_8x128_and3_dec_79/C
+ routeb_new_1w1r_8x128_and3_dec_95/B routeb_new_1w1r_8x128_and3_dec_9/A routeb_new_1w1r_8x128_and3_dec
Xrouteb_new_1w1r_8x128_and3_dec_66 decode_61 vdd_uq17 vdd_uq19 gnd routeb_new_1w1r_8x128_and3_dec_79/C
+ routeb_new_1w1r_8x128_and3_dec_3/B routeb_new_1w1r_8x128_and3_dec_6/A routeb_new_1w1r_8x128_and3_dec
Xrouteb_new_1w1r_8x128_and3_dec_55 decode_72 vdd_uq17 vdd_uq19 gnd routeb_new_1w1r_8x128_and3_dec_63/C
+ routeb_new_1w1r_8x128_and3_dec_7/B routeb_new_1w1r_8x128_and3_dec_7/A routeb_new_1w1r_8x128_and3_dec
Xrouteb_new_1w1r_8x128_and3_dec_44 decode_83 vdd_uq17 vdd_uq19 gnd routeb_new_1w1r_8x128_and3_dec_47/C
+ routeb_new_1w1r_8x128_and3_dec_95/B routeb_new_1w1r_8x128_and3_dec_8/A routeb_new_1w1r_8x128_and3_dec
Xrouteb_new_1w1r_8x128_and3_dec_6 decode_121 vdd_uq17 vdd_uq19 gnd routeb_new_1w1r_8x128_and3_dec_9/C
+ routeb_new_1w1r_8x128_and3_dec_7/B routeb_new_1w1r_8x128_and3_dec_6/A routeb_new_1w1r_8x128_and3_dec
Xrouteb_new_1w1r_8x128_and3_dec_12 decode_115 vdd_uq17 vdd_uq19 gnd routeb_new_1w1r_8x128_and3_dec_9/C
+ routeb_new_1w1r_8x128_and3_dec_95/B routeb_new_1w1r_8x128_and3_dec_8/A routeb_new_1w1r_8x128_and3_dec
Xrouteb_new_1w1r_8x128_and3_dec_23 decode_104 vdd_uq17 vdd_uq19 gnd routeb_new_1w1r_8x128_and3_dec_31/C
+ routeb_new_1w1r_8x128_and3_dec_7/B routeb_new_1w1r_8x128_and3_dec_7/A routeb_new_1w1r_8x128_and3_dec
Xrouteb_new_1w1r_8x128_and3_dec_34 decode_93 vdd_uq17 vdd_uq19 gnd routeb_new_1w1r_8x128_and3_dec_47/C
+ routeb_new_1w1r_8x128_and3_dec_3/B routeb_new_1w1r_8x128_and3_dec_6/A routeb_new_1w1r_8x128_and3_dec
Xrouteb_new_1w1r_8x128_and3_dec_89 decode_38 vdd_uq17 vdd_uq19 gnd routeb_new_1w1r_8x128_and3_dec_95/C
+ routeb_new_1w1r_8x128_and3_dec_9/B routeb_new_1w1r_8x128_and3_dec_9/A routeb_new_1w1r_8x128_and3_dec
Xrouteb_new_1w1r_8x128_and3_dec_78 decode_49 vdd_uq17 vdd_uq19 gnd routeb_new_1w1r_8x128_and3_dec_79/C
+ routeb_new_1w1r_8x128_and3_dec_95/B routeb_new_1w1r_8x128_and3_dec_6/A routeb_new_1w1r_8x128_and3_dec
Xrouteb_new_1w1r_8x128_and3_dec_67 decode_60 vdd_uq17 vdd_uq19 gnd routeb_new_1w1r_8x128_and3_dec_79/C
+ routeb_new_1w1r_8x128_and3_dec_3/B routeb_new_1w1r_8x128_and3_dec_7/A routeb_new_1w1r_8x128_and3_dec
Xrouteb_new_1w1r_8x128_and3_dec_56 decode_71 vdd_uq17 vdd_uq19 gnd routeb_new_1w1r_8x128_and3_dec_63/C
+ routeb_new_1w1r_8x128_and3_dec_9/B routeb_new_1w1r_8x128_and3_dec_8/A routeb_new_1w1r_8x128_and3_dec
Xrouteb_new_1w1r_8x128_and3_dec_45 decode_82 vdd_uq17 vdd_uq19 gnd routeb_new_1w1r_8x128_and3_dec_47/C
+ routeb_new_1w1r_8x128_and3_dec_95/B routeb_new_1w1r_8x128_and3_dec_9/A routeb_new_1w1r_8x128_and3_dec
Xrouteb_new_1w1r_8x128_and3_dec_13 decode_114 vdd_uq17 vdd_uq19 gnd routeb_new_1w1r_8x128_and3_dec_9/C
+ routeb_new_1w1r_8x128_and3_dec_95/B routeb_new_1w1r_8x128_and3_dec_9/A routeb_new_1w1r_8x128_and3_dec
Xrouteb_new_1w1r_8x128_and3_dec_24 decode_103 vdd_uq17 vdd_uq19 gnd routeb_new_1w1r_8x128_and3_dec_31/C
+ routeb_new_1w1r_8x128_and3_dec_9/B routeb_new_1w1r_8x128_and3_dec_8/A routeb_new_1w1r_8x128_and3_dec
Xrouteb_new_1w1r_8x128_and3_dec_79 decode_48 vdd_uq17 vdd_uq19 gnd routeb_new_1w1r_8x128_and3_dec_79/C
+ routeb_new_1w1r_8x128_and3_dec_95/B routeb_new_1w1r_8x128_and3_dec_7/A routeb_new_1w1r_8x128_and3_dec
Xrouteb_new_1w1r_8x128_and3_dec_68 decode_59 vdd_uq17 vdd_uq19 gnd routeb_new_1w1r_8x128_and3_dec_79/C
+ routeb_new_1w1r_8x128_and3_dec_7/B routeb_new_1w1r_8x128_and3_dec_8/A routeb_new_1w1r_8x128_and3_dec
Xrouteb_new_1w1r_8x128_and3_dec_57 decode_70 vdd_uq17 vdd_uq19 gnd routeb_new_1w1r_8x128_and3_dec_63/C
+ routeb_new_1w1r_8x128_and3_dec_9/B routeb_new_1w1r_8x128_and3_dec_9/A routeb_new_1w1r_8x128_and3_dec
Xrouteb_new_1w1r_8x128_and3_dec_46 decode_81 vdd_uq17 vdd_uq19 gnd routeb_new_1w1r_8x128_and3_dec_47/C
+ routeb_new_1w1r_8x128_and3_dec_95/B routeb_new_1w1r_8x128_and3_dec_6/A routeb_new_1w1r_8x128_and3_dec
Xrouteb_new_1w1r_8x128_and3_dec_35 decode_92 vdd_uq17 vdd_uq19 gnd routeb_new_1w1r_8x128_and3_dec_47/C
+ routeb_new_1w1r_8x128_and3_dec_3/B routeb_new_1w1r_8x128_and3_dec_7/A routeb_new_1w1r_8x128_and3_dec
Xrouteb_new_1w1r_8x128_and3_dec_7 decode_120 vdd_uq17 vdd_uq19 gnd routeb_new_1w1r_8x128_and3_dec_9/C
+ routeb_new_1w1r_8x128_and3_dec_7/B routeb_new_1w1r_8x128_and3_dec_7/A routeb_new_1w1r_8x128_and3_dec
.ends
